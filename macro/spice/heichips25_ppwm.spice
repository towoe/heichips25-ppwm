* NGSPICE file created from heichips25_ppwm.ext - technology: ihp-sg13g2

* Black-box entry subcircuit for sg13g2_fill_2 abstract view
.subckt sg13g2_fill_2 VDD VSS
.ends

* Black-box entry subcircuit for sg13g2_decap_8 abstract view
.subckt sg13g2_decap_8 VDD VSS
.ends

* Black-box entry subcircuit for sg13g2_dfrbpq_1 abstract view
.subckt sg13g2_dfrbpq_1 RESET_B VSS VDD D Q CLK
.ends

* Black-box entry subcircuit for sg13g2_o21ai_1 abstract view
.subckt sg13g2_o21ai_1 B1 VDD Y VSS A1 A2
.ends

* Black-box entry subcircuit for sg13g2_fill_1 abstract view
.subckt sg13g2_fill_1 VDD VSS
.ends

* Black-box entry subcircuit for sg13g2_nor2_2 abstract view
.subckt sg13g2_nor2_2 A B Y VDD VSS
.ends

* Black-box entry subcircuit for sg13g2_dlygate4sd3_1 abstract view
.subckt sg13g2_dlygate4sd3_1 A VDD VSS X
.ends

* Black-box entry subcircuit for sg13g2_decap_4 abstract view
.subckt sg13g2_decap_4 VDD VSS
.ends

* Black-box entry subcircuit for sg13g2_a21oi_1 abstract view
.subckt sg13g2_a21oi_1 VSS VDD A1 A2 Y B1
.ends

* Black-box entry subcircuit for sg13g2_dfrbpq_2 abstract view
.subckt sg13g2_dfrbpq_2 RESET_B VSS VDD D Q CLK
.ends

* Black-box entry subcircuit for sg13g2_nor2_1 abstract view
.subckt sg13g2_nor2_1 A B Y VDD VSS
.ends

* Black-box entry subcircuit for sg13g2_xor2_1 abstract view
.subckt sg13g2_xor2_1 B A X VDD VSS
.ends

* Black-box entry subcircuit for sg13g2_buf_8 abstract view
.subckt sg13g2_buf_8 A X VDD VSS
.ends

* Black-box entry subcircuit for sg13g2_tielo abstract view
.subckt sg13g2_tielo VDD VSS L_LO
.ends

* Black-box entry subcircuit for sg13g2_and2_1 abstract view
.subckt sg13g2_and2_1 A B X VDD VSS
.ends

* Black-box entry subcircuit for sg13g2_nand2b_1 abstract view
.subckt sg13g2_nand2b_1 Y B A_N VDD VSS
.ends

* Black-box entry subcircuit for sg13g2_inv_1 abstract view
.subckt sg13g2_inv_1 VDD Y A VSS
.ends

* Black-box entry subcircuit for sg13g2_tiehi abstract view
.subckt sg13g2_tiehi VDD VSS L_HI
.ends

* Black-box entry subcircuit for sg13g2_nor3_1 abstract view
.subckt sg13g2_nor3_1 A B C Y VDD VSS
.ends

* Black-box entry subcircuit for sg13g2_a22oi_1 abstract view
.subckt sg13g2_a22oi_1 Y B1 B2 A2 A1 VDD VSS
.ends

* Black-box entry subcircuit for sg13g2_and3_1 abstract view
.subckt sg13g2_and3_1 X A B C VDD VSS
.ends

* Black-box entry subcircuit for sg13g2_nand2_1 abstract view
.subckt sg13g2_nand2_1 Y A B VDD VSS
.ends

* Black-box entry subcircuit for sg13g2_a21o_1 abstract view
.subckt sg13g2_a21o_1 A2 A1 B1 X VDD VSS
.ends

* Black-box entry subcircuit for sg13g2_nand4_1 abstract view
.subckt sg13g2_nand4_1 B C A Y VDD VSS D
.ends

* Black-box entry subcircuit for sg13g2_mux2_1 abstract view
.subckt sg13g2_mux2_1 A0 A1 S X VDD VSS
.ends

* Black-box entry subcircuit for sg13g2_nor2b_1 abstract view
.subckt sg13g2_nor2b_1 A B_N Y VDD VSS
.ends

* Black-box entry subcircuit for sg13g2_buf_2 abstract view
.subckt sg13g2_buf_2 A X VDD VSS
.ends

* Black-box entry subcircuit for sg13g2_a221oi_1 abstract view
.subckt sg13g2_a221oi_1 VDD VSS B2 C1 B1 A1 Y A2
.ends

* Black-box entry subcircuit for sg13g2_nand3_1 abstract view
.subckt sg13g2_nand3_1 B C A Y VDD VSS
.ends

* Black-box entry subcircuit for sg13g2_nor4_1 abstract view
.subckt sg13g2_nor4_1 A B C D Y VDD VSS
.ends

* Black-box entry subcircuit for sg13g2_nand3b_1 abstract view
.subckt sg13g2_nand3b_1 B C Y VDD VSS A_N
.ends

* Black-box entry subcircuit for sg13g2_or4_1 abstract view
.subckt sg13g2_or4_1 A B C D X VDD VSS
.ends

* Black-box entry subcircuit for sg13g2_a21oi_2 abstract view
.subckt sg13g2_a21oi_2 VSS VDD B1 Y A2 A1
.ends

* Black-box entry subcircuit for sg13g2_or2_1 abstract view
.subckt sg13g2_or2_1 VSS VDD X B A
.ends

* Black-box entry subcircuit for sg13g2_inv_4 abstract view
.subckt sg13g2_inv_4 A Y VDD VSS
.ends

* Black-box entry subcircuit for sg13g2_or3_1 abstract view
.subckt sg13g2_or3_1 A B C X VDD VSS
.ends

* Black-box entry subcircuit for sg13g2_buf_1 abstract view
.subckt sg13g2_buf_1 A X VDD VSS
.ends

* Black-box entry subcircuit for sg13g2_mux4_1 abstract view
.subckt sg13g2_mux4_1 S0 A0 A1 A2 A3 S1 X VDD VSS
.ends

* Black-box entry subcircuit for sg13g2_inv_2 abstract view
.subckt sg13g2_inv_2 Y A VDD VSS
.ends

* Black-box entry subcircuit for sg13g2_xnor2_1 abstract view
.subckt sg13g2_xnor2_1 Y A B VDD VSS
.ends

* Black-box entry subcircuit for sg13g2_nor4_2 abstract view
.subckt sg13g2_nor4_2 A B C Y VSS VDD D
.ends

* Black-box entry subcircuit for sg13g2_nor2b_2 abstract view
.subckt sg13g2_nor2b_2 A B_N Y VDD VSS
.ends

* Black-box entry subcircuit for sg13g2_nand2_2 abstract view
.subckt sg13g2_nand2_2 Y A B VDD VSS
.ends

* Black-box entry subcircuit for sg13g2_and4_1 abstract view
.subckt sg13g2_and4_1 A B C D X VDD VSS
.ends

* Black-box entry subcircuit for sg13g2_and3_2 abstract view
.subckt sg13g2_and3_2 X A B C VDD VSS
.ends

* Black-box entry subcircuit for sg13g2_nor3_2 abstract view
.subckt sg13g2_nor3_2 A B C Y VDD VSS
.ends

* Black-box entry subcircuit for sg13g2_a21o_2 abstract view
.subckt sg13g2_a21o_2 A2 A1 B1 X VDD VSS
.ends

.subckt heichips25_ppwm VGND VPWR clk ena rst_n ui_in[0] ui_in[1] ui_in[2] ui_in[3]
+ ui_in[4] ui_in[5] ui_in[6] ui_in[7] uio_in[0] uio_in[1] uio_in[2] uio_in[3] uio_in[4]
+ uio_in[5] uio_in[6] uio_in[7] uio_oe[0] uio_oe[1] uio_oe[2] uio_oe[3] uio_oe[4]
+ uio_oe[5] uio_oe[6] uio_oe[7] uio_out[0] uio_out[1] uio_out[2] uio_out[3] uio_out[4]
+ uio_out[5] uio_out[6] uio_out[7] uo_out[0] uo_out[1] uo_out[2] uo_out[3] uo_out[4]
+ uo_out[5] uo_out[6] uo_out[7]
XFILLER_35_450 VPWR VGND sg13g2_fill_2
XFILLER_23_623 VPWR VGND sg13g2_decap_8
XFILLER_36_984 VPWR VGND sg13g2_decap_8
XFILLER_22_122 VPWR VGND sg13g2_decap_8
XFILLER_11_829 VPWR VGND sg13g2_decap_8
XFILLER_19_907 VPWR VGND sg13g2_decap_8
XFILLER_18_406 VPWR VGND sg13g2_fill_2
XFILLER_46_748 VPWR VGND sg13g2_decap_8
XFILLER_45_247 VPWR VGND sg13g2_fill_2
XFILLER_26_52 VPWR VGND sg13g2_fill_2
XFILLER_27_995 VPWR VGND sg13g2_decap_8
XFILLER_42_965 VPWR VGND sg13g2_decap_8
XFILLER_26_494 VPWR VGND sg13g2_decap_8
XFILLER_41_475 VPWR VGND sg13g2_decap_8
XFILLER_14_667 VPWR VGND sg13g2_decap_8
XFILLER_42_51 VPWR VGND sg13g2_fill_2
Xu_ppwm_u_pwm__251_ net208 VGND VPWR net288 hold70/A clknet_5_6__leaf_clk sg13g2_dfrbpq_1
Xu_ppwm_u_pwm__182_ net478 VPWR u_ppwm_u_pwm__182_/Y VGND hold301/A net378 sg13g2_o21ai_1
XFILLER_6_855 VPWR VGND sg13g2_decap_8
XFILLER_5_310 VPWR VGND sg13g2_fill_1
XFILLER_10_873 VPWR VGND sg13g2_decap_8
XFILLER_5_398 VPWR VGND sg13g2_decap_8
XFILLER_3_89 VPWR VGND sg13g2_fill_2
XFILLER_49_586 VPWR VGND sg13g2_decap_8
XFILLER_45_781 VPWR VGND sg13g2_decap_8
XFILLER_18_984 VPWR VGND sg13g2_decap_8
XFILLER_33_921 VPWR VGND sg13g2_decap_8
XFILLER_20_615 VPWR VGND sg13g2_decap_8
XFILLER_32_464 VPWR VGND sg13g2_fill_2
XFILLER_33_998 VPWR VGND sg13g2_decap_8
Xu_ppwm_u_ex__0995_ u_ppwm_u_ex__0995_/A u_ppwm_u_ex__0995_/B fanout343/A VPWR VGND
+ sg13g2_nor2_2
XFILLER_9_682 VPWR VGND sg13g2_decap_8
XFILLER_43_729 VPWR VGND sg13g2_decap_8
XFILLER_36_781 VPWR VGND sg13g2_decap_8
XFILLER_24_943 VPWR VGND sg13g2_decap_8
XFILLER_11_626 VPWR VGND sg13g2_decap_8
XFILLER_23_497 VPWR VGND sg13g2_decap_8
XFILLER_12_43 VPWR VGND sg13g2_fill_2
XFILLER_12_76 VPWR VGND sg13g2_fill_1
XFILLER_3_847 VPWR VGND sg13g2_decap_8
Xhold170 hold170/A VPWR VGND net553 sg13g2_dlygate4sd3_1
Xhold181 hold181/A VPWR VGND net564 sg13g2_dlygate4sd3_1
Xhold192 hold192/A VPWR VGND net575 sg13g2_dlygate4sd3_1
XFILLER_19_704 VPWR VGND sg13g2_decap_8
XFILLER_46_545 VPWR VGND sg13g2_decap_8
XFILLER_18_258 VPWR VGND sg13g2_decap_4
XFILLER_37_84 VPWR VGND sg13g2_fill_1
XFILLER_27_792 VPWR VGND sg13g2_decap_8
XFILLER_42_762 VPWR VGND sg13g2_decap_8
XFILLER_15_976 VPWR VGND sg13g2_decap_8
XFILLER_18_1026 VPWR VGND sg13g2_fill_2
XFILLER_30_913 VPWR VGND sg13g2_decap_8
XFILLER_41_261 VPWR VGND sg13g2_decap_4
Xu_ppwm_u_ex__0780_ u_ppwm_u_ex__0896_/B net359 fanout347/A VPWR VGND sg13g2_nor2_2
Xu_ppwm_u_mem__0992_ VGND VPWR u_ppwm_u_mem__0636_/Y net388 hold40/A u_ppwm_u_mem__0991_/Y
+ sg13g2_a21oi_1
Xu_ppwm_u_pwm__234_ net196 VGND VPWR net573 hold231/A clknet_5_4__leaf_clk sg13g2_dfrbpq_2
XFILLER_10_670 VPWR VGND sg13g2_decap_8
Xu_ppwm_u_pwm__165_ net619 u_ppwm_u_pwm__166_/B hold237/A VPWR VGND sg13g2_nor2_1
XFILLER_6_652 VPWR VGND sg13g2_decap_8
XFILLER_5_173 VPWR VGND sg13g2_decap_4
XFILLER_25_1019 VPWR VGND sg13g2_decap_8
XFILLER_49_383 VPWR VGND sg13g2_decap_8
XFILLER_37_567 VPWR VGND sg13g2_decap_8
XFILLER_18_781 VPWR VGND sg13g2_decap_8
XFILLER_25_718 VPWR VGND sg13g2_decap_8
XFILLER_17_280 VPWR VGND sg13g2_fill_2
XFILLER_24_228 VPWR VGND sg13g2_fill_2
XFILLER_32_250 VPWR VGND sg13g2_fill_1
XFILLER_20_401 VPWR VGND sg13g2_fill_2
XFILLER_20_412 VPWR VGND sg13g2_fill_1
XFILLER_21_946 VPWR VGND sg13g2_decap_8
XFILLER_33_795 VPWR VGND sg13g2_decap_8
Xu_ppwm_u_ex__0978_ net362 net654 u_ppwm_u_ex__0978_/X VPWR VGND sg13g2_xor2_1
XFILLER_20_489 VPWR VGND sg13g2_decap_8
Xclkbuf_4_12_0_clk clknet_0_clk clknet_4_12_0_clk VPWR VGND sg13g2_buf_8
Xheichips25_ppwm_11 VPWR VGND uio_oe[7] sg13g2_tielo
Xheichips25_ppwm_22 VPWR VGND uo_out[3] sg13g2_tielo
XFILLER_28_567 VPWR VGND sg13g2_decap_8
XFILLER_43_526 VPWR VGND sg13g2_decap_8
XFILLER_15_217 VPWR VGND sg13g2_decap_4
XFILLER_24_740 VPWR VGND sg13g2_decap_8
XFILLER_11_423 VPWR VGND sg13g2_fill_1
XFILLER_8_906 VPWR VGND sg13g2_decap_8
XFILLER_12_968 VPWR VGND sg13g2_decap_8
XFILLER_7_449 VPWR VGND sg13g2_decap_8
XFILLER_3_644 VPWR VGND sg13g2_decap_8
XFILLER_47_821 VPWR VGND sg13g2_decap_8
Xfanout480 net482 net480 VPWR VGND sg13g2_buf_8
XFILLER_19_501 VPWR VGND sg13g2_decap_8
Xfanout491 net492 net491 VPWR VGND sg13g2_buf_8
XFILLER_0_35 VPWR VGND sg13g2_decap_8
Xu_ppwm_u_mem__1191_ net192 VGND VPWR u_ppwm_u_mem__1191_/D hold131/A clknet_5_25__leaf_clk
+ sg13g2_dfrbpq_1
XFILLER_47_898 VPWR VGND sg13g2_decap_8
XFILLER_19_578 VPWR VGND sg13g2_decap_8
XFILLER_15_773 VPWR VGND sg13g2_decap_8
Xu_ppwm_u_ex__0901_ u_ppwm_u_ex__0901_/A u_ppwm_u_ex__0901_/B u_ppwm_u_ex__1048_/A
+ VPWR VGND sg13g2_and2_1
XFILLER_30_710 VPWR VGND sg13g2_decap_8
Xu_ppwm_u_ex__0832_ net352 u_ppwm_u_ex__0832_/B u_ppwm_u_ex__0832_/Y VPWR VGND sg13g2_nor2_1
XFILLER_30_787 VPWR VGND sg13g2_decap_8
Xu_ppwm_u_ex__0763_ u_ppwm_u_ex__0763_/Y net432 hold291/A VPWR VGND sg13g2_nand2b_1
Xu_ppwm_u_pwm__217_ u_ppwm_u_pwm__222_/B hold245/A hold18/A VPWR VGND sg13g2_nand2b_1
XFILLER_11_990 VPWR VGND sg13g2_decap_8
Xu_ppwm_u_mem__0975_ net481 VPWR u_ppwm_u_mem__0975_/Y VGND net298 net387 sg13g2_o21ai_1
Xu_ppwm_u_ex__0694_ u_ppwm_u_ex__0694_/Y hold271/A net430 VPWR VGND sg13g2_nand2b_1
Xu_ppwm_u_pwm__148_ VGND VPWR u_ppwm_u_pwm__154_/A net588 hold206/A u_ppwm_u_pwm__147_/Y
+ sg13g2_a21oi_1
Xu_ppwm_u_global_counter__166_ net74 VGND VPWR u_ppwm_u_global_counter__166_/D hold291/A
+ clknet_5_16__leaf_clk sg13g2_dfrbpq_2
XFILLER_38_854 VPWR VGND sg13g2_decap_8
XFILLER_25_515 VPWR VGND sg13g2_decap_8
Xu_ppwm_u_global_counter__097_ VPWR u_ppwm_u_global_counter__120_/A net674 VGND sg13g2_inv_1
XFILLER_21_743 VPWR VGND sg13g2_decap_8
XFILLER_33_592 VPWR VGND sg13g2_decap_8
Xu_ppwm_u_ex__1132__32 VPWR VGND net32 sg13g2_tiehi
XFILLER_5_909 VPWR VGND sg13g2_decap_8
XFILLER_48_618 VPWR VGND sg13g2_decap_8
XFILLER_0_658 VPWR VGND sg13g2_decap_8
XFILLER_47_106 VPWR VGND sg13g2_decap_8
XFILLER_29_843 VPWR VGND sg13g2_decap_8
XFILLER_44_824 VPWR VGND sg13g2_decap_8
XFILLER_16_548 VPWR VGND sg13g2_decap_8
XFILLER_34_52 VPWR VGND sg13g2_fill_1
XFILLER_8_703 VPWR VGND sg13g2_decap_8
XFILLER_12_765 VPWR VGND sg13g2_decap_8
XFILLER_15_1018 VPWR VGND sg13g2_decap_8
XFILLER_7_257 VPWR VGND sg13g2_fill_1
Xu_ppwm_u_mem__0760_ net453 u_ppwm_u_mem__0760_/B u_ppwm_u_mem__0760_/Y VPWR VGND
+ sg13g2_nor2_1
Xu_ppwm_u_mem__0691_ VPWR u_ppwm_u_mem__0691_/Y net532 VGND sg13g2_inv_1
XFILLER_4_942 VPWR VGND sg13g2_decap_8
XFILLER_3_441 VPWR VGND sg13g2_decap_8
Xu_ppwm_u_ex__1100_ u_ppwm_u_ex__1100_/A u_ppwm_u_ex__1100_/B u_ppwm_u_ex__1100_/C
+ u_ppwm_u_ex__1102_/A VPWR VGND sg13g2_nor3_1
Xu_ppwm_u_ex__1031_ u_ppwm_u_ex__1031_/Y net348 hold288/A fanout359/A hold278/A VPWR
+ VGND sg13g2_a22oi_1
Xu_ppwm_u_mem__1174_ net190 VGND VPWR u_ppwm_u_mem__1174_/D hold168/A clknet_5_29__leaf_clk
+ sg13g2_dfrbpq_1
XFILLER_47_695 VPWR VGND sg13g2_decap_8
XFILLER_35_835 VPWR VGND sg13g2_decap_8
Xu_ppwm_u_mem__1150__167 VPWR VGND net167 sg13g2_tiehi
XFILLER_43_890 VPWR VGND sg13g2_decap_8
XFILLER_15_570 VPWR VGND sg13g2_decap_8
XFILLER_22_518 VPWR VGND sg13g2_decap_8
Xu_ppwm_u_ex__0815_ fanout346/A net616 u_ppwm_u_ex__0815_/B u_ppwm_u_ex__0815_/C VPWR
+ VGND sg13g2_and3_1
XFILLER_30_584 VPWR VGND sg13g2_decap_8
Xu_ppwm_u_ex__0746_ u_ppwm_u_ex__0746_/Y u_ppwm_u_ex__0746_/A u_ppwm_u_ex__0746_/B
+ VPWR VGND sg13g2_nand2_1
Xu_ppwm_u_mem__0958_ VGND VPWR u_ppwm_u_mem__0653_/Y net385 u_ppwm_u_mem__1149_/D
+ u_ppwm_u_mem__0957_/Y sg13g2_a21oi_1
Xu_ppwm_u_mem__0889_ net489 VPWR u_ppwm_u_mem__0889_/Y VGND net293 net403 sg13g2_o21ai_1
Xu_ppwm_u_ex__0677_ u_ppwm_u_ex__0673_/Y u_ppwm_u_ex__0672_/Y u_ppwm_u_ex__0676_/Y
+ u_ppwm_u_ex__0677_/X VPWR VGND sg13g2_a21o_1
XFILLER_26_802 VPWR VGND sg13g2_decap_8
XFILLER_38_651 VPWR VGND sg13g2_decap_8
Xu_ppwm_u_global_counter__149_ net422 net423 net639 u_ppwm_u_global_counter__150_/B
+ VPWR VGND u_ppwm_u_global_counter__156_/C sg13g2_nand4_1
XFILLER_26_879 VPWR VGND sg13g2_decap_8
XFILLER_13_518 VPWR VGND sg13g2_decap_8
XFILLER_21_540 VPWR VGND sg13g2_decap_8
XFILLER_5_706 VPWR VGND sg13g2_decap_8
Xu_ppwm_u_ex__1120__35 VPWR VGND net35 sg13g2_tiehi
XFILLER_1_923 VPWR VGND sg13g2_decap_8
XFILLER_0_455 VPWR VGND sg13g2_decap_8
XFILLER_48_415 VPWR VGND sg13g2_decap_8
Xhold41 hold41/A VPWR VGND net258 sg13g2_dlygate4sd3_1
Xhold30 hold30/A VPWR VGND net247 sg13g2_dlygate4sd3_1
Xhold74 hold74/A VPWR VGND net291 sg13g2_dlygate4sd3_1
XFILLER_29_96 VPWR VGND sg13g2_fill_1
XFILLER_29_640 VPWR VGND sg13g2_decap_8
Xhold52 hold52/A VPWR VGND net269 sg13g2_dlygate4sd3_1
Xhold63 hold63/A VPWR VGND net280 sg13g2_dlygate4sd3_1
Xhold96 hold96/A VPWR VGND net313 sg13g2_dlygate4sd3_1
Xhold85 hold85/A VPWR VGND net302 sg13g2_dlygate4sd3_1
XFILLER_44_621 VPWR VGND sg13g2_decap_8
XFILLER_17_846 VPWR VGND sg13g2_decap_8
XFILLER_28_161 VPWR VGND sg13g2_fill_1
XFILLER_43_120 VPWR VGND sg13g2_decap_4
XFILLER_32_816 VPWR VGND sg13g2_decap_8
XFILLER_44_698 VPWR VGND sg13g2_decap_8
XFILLER_43_197 VPWR VGND sg13g2_decap_8
XFILLER_8_500 VPWR VGND sg13g2_decap_8
XFILLER_12_562 VPWR VGND sg13g2_decap_8
Xu_ppwm_u_mem__0812_ hold107/A hold12/A net472 u_ppwm_u_mem__0812_/X VPWR VGND sg13g2_mux2_1
XFILLER_8_577 VPWR VGND sg13g2_decap_8
Xu_ppwm_u_ex__0600_ VPWR u_ppwm_u_ex__0600_/Y hold234/A VGND sg13g2_inv_1
Xu_ppwm_u_mem__0743_ net459 VPWR u_ppwm_u_mem__0743_/Y VGND hold67/A net469 sg13g2_o21ai_1
Xu_ppwm_u_mem__0674_ VPWR u_ppwm_u_mem__0674_/Y net533 VGND sg13g2_inv_1
XFILLER_6_1027 VPWR VGND sg13g2_fill_2
XFILLER_6_1016 VPWR VGND sg13g2_decap_8
XFILLER_20_4 VPWR VGND sg13g2_decap_4
XFILLER_48_982 VPWR VGND sg13g2_decap_8
XFILLER_47_492 VPWR VGND sg13g2_decap_8
Xu_ppwm_u_ex__1014_ net366 net439 u_ppwm_u_ex__1016_/B VPWR VGND sg13g2_xor2_1
XFILLER_35_632 VPWR VGND sg13g2_decap_8
XFILLER_19_194 VPWR VGND sg13g2_fill_1
XFILLER_23_805 VPWR VGND sg13g2_decap_8
XFILLER_34_131 VPWR VGND sg13g2_fill_1
Xu_ppwm_u_mem__1157_ net139 VGND VPWR net320 hold102/A clknet_5_15__leaf_clk sg13g2_dfrbpq_1
Xu_ppwm_u_mem__1088_ net194 VGND VPWR net222 hold4/A clknet_5_12__leaf_clk sg13g2_dfrbpq_1
XFILLER_22_337 VPWR VGND sg13g2_decap_4
Xu_ppwm_u_ex__0729_ u_ppwm_u_ex__0729_/Y u_ppwm_u_ex__0595_/Y net431 u_ppwm_u_ex__0722_/B
+ net430 VPWR VGND sg13g2_a22oi_1
XFILLER_14_849 VPWR VGND sg13g2_decap_8
XFILLER_15_32 VPWR VGND sg13g2_decap_4
XFILLER_26_676 VPWR VGND sg13g2_decap_8
XFILLER_41_657 VPWR VGND sg13g2_decap_8
XFILLER_15_76 VPWR VGND sg13g2_decap_4
XFILLER_22_882 VPWR VGND sg13g2_decap_8
XFILLER_5_503 VPWR VGND sg13g2_decap_8
XFILLER_1_720 VPWR VGND sg13g2_decap_8
XFILLER_49_768 VPWR VGND sg13g2_decap_8
XFILLER_1_797 VPWR VGND sg13g2_decap_8
XFILLER_45_963 VPWR VGND sg13g2_decap_8
XFILLER_17_643 VPWR VGND sg13g2_decap_8
Xu_ppwm_u_mem__1011_ net503 VPWR u_ppwm_u_mem__1011_/Y VGND hold199/A net417 sg13g2_o21ai_1
XFILLER_32_613 VPWR VGND sg13g2_decap_8
XFILLER_44_495 VPWR VGND sg13g2_decap_8
XFILLER_31_123 VPWR VGND sg13g2_decap_4
XFILLER_31_156 VPWR VGND sg13g2_fill_1
XFILLER_13_882 VPWR VGND sg13g2_decap_8
XFILLER_9_864 VPWR VGND sg13g2_decap_8
Xclkbuf_5_17__f_clk clknet_4_8_0_clk clknet_5_17__leaf_clk VPWR VGND sg13g2_buf_8
XFILLER_8_374 VPWR VGND sg13g2_fill_1
Xu_ppwm_u_mem__0726_ hold24/A net466 u_ppwm_u_mem__0726_/Y VPWR VGND sg13g2_nor2b_1
Xu_ppwm_u_mem__0657_ VPWR u_ppwm_u_mem__0657_/Y net243 VGND sg13g2_inv_1
Xu_ppwm_u_mem__1209_ net484 VGND VPWR net219 u_ppwm_u_mem__1209_/Q clknet_5_2__leaf_clk
+ sg13g2_dfrbpq_1
XFILLER_36_963 VPWR VGND sg13g2_decap_8
XFILLER_23_602 VPWR VGND sg13g2_decap_8
XFILLER_11_808 VPWR VGND sg13g2_decap_8
XFILLER_23_679 VPWR VGND sg13g2_decap_8
Xu_ppwm_u_mem__1100__150 VPWR VGND net150 sg13g2_tiehi
XFILLER_46_727 VPWR VGND sg13g2_decap_8
XFILLER_45_204 VPWR VGND sg13g2_decap_4
XFILLER_26_473 VPWR VGND sg13g2_decap_8
XFILLER_27_974 VPWR VGND sg13g2_decap_8
XFILLER_42_944 VPWR VGND sg13g2_decap_8
XFILLER_14_646 VPWR VGND sg13g2_decap_8
Xu_ppwm_u_pwm__250_ net212 VGND VPWR net264 hold46/A clknet_5_6__leaf_clk sg13g2_dfrbpq_1
XFILLER_13_178 VPWR VGND sg13g2_decap_8
Xu_ppwm_u_pwm__181_ VGND VPWR u_ppwm_u_pwm__137_/Y net378 hold7/A u_ppwm_u_pwm__180_/Y
+ sg13g2_a21oi_1
XFILLER_10_852 VPWR VGND sg13g2_decap_8
XFILLER_6_834 VPWR VGND sg13g2_decap_8
Xu_ppwm_u_pwm__246__206 VPWR VGND net206 sg13g2_tiehi
XFILLER_1_594 VPWR VGND sg13g2_decap_8
XFILLER_49_565 VPWR VGND sg13g2_decap_8
XFILLER_3_1008 VPWR VGND sg13g2_decap_8
XFILLER_37_749 VPWR VGND sg13g2_decap_8
XFILLER_18_963 VPWR VGND sg13g2_decap_8
XFILLER_45_760 VPWR VGND sg13g2_decap_8
XFILLER_33_900 VPWR VGND sg13g2_decap_8
XFILLER_32_421 VPWR VGND sg13g2_decap_4
XFILLER_33_977 VPWR VGND sg13g2_decap_8
Xu_ppwm_u_ex__0994_ VGND VPWR net377 u_ppwm_u_ex__0813_/A u_ppwm_u_ex__0995_/B u_ppwm_u_ex__0993_/Y
+ sg13g2_a21oi_1
XFILLER_32_487 VPWR VGND sg13g2_decap_8
XFILLER_9_661 VPWR VGND sg13g2_decap_8
XFILLER_8_160 VPWR VGND sg13g2_decap_4
Xu_ppwm_u_mem__0709_ VPWR u_ppwm_u_mem__0709_/Y net305 VGND sg13g2_inv_1
Xu_ppwm_u_global_counter__160__57 VPWR VGND net57 sg13g2_tiehi
XFILLER_41_1014 VPWR VGND sg13g2_decap_8
XFILLER_28_749 VPWR VGND sg13g2_decap_8
XFILLER_43_708 VPWR VGND sg13g2_decap_8
XFILLER_27_248 VPWR VGND sg13g2_decap_4
XFILLER_24_922 VPWR VGND sg13g2_decap_8
XFILLER_36_760 VPWR VGND sg13g2_decap_8
XFILLER_11_605 VPWR VGND sg13g2_decap_8
XFILLER_24_999 VPWR VGND sg13g2_decap_8
XFILLER_23_476 VPWR VGND sg13g2_decap_8
XFILLER_3_826 VPWR VGND sg13g2_decap_8
XFILLER_2_336 VPWR VGND sg13g2_fill_1
Xhold160 hold160/A VPWR VGND net543 sg13g2_dlygate4sd3_1
Xhold171 hold171/A VPWR VGND net554 sg13g2_dlygate4sd3_1
Xhold193 hold193/A VPWR VGND net576 sg13g2_dlygate4sd3_1
Xhold182 hold182/A VPWR VGND net565 sg13g2_dlygate4sd3_1
XFILLER_46_524 VPWR VGND sg13g2_decap_8
XFILLER_18_226 VPWR VGND sg13g2_fill_1
XFILLER_37_63 VPWR VGND sg13g2_fill_2
XFILLER_37_74 VPWR VGND sg13g2_fill_1
XFILLER_27_771 VPWR VGND sg13g2_decap_8
XFILLER_42_741 VPWR VGND sg13g2_decap_8
XFILLER_15_955 VPWR VGND sg13g2_decap_8
XFILLER_41_251 VPWR VGND sg13g2_fill_1
XFILLER_14_443 VPWR VGND sg13g2_decap_8
XFILLER_18_1005 VPWR VGND sg13g2_decap_8
Xu_ppwm_u_pwm__233_ VGND VPWR net225 u_ppwm_u_pwm__231_/Y hold9/A u_ppwm_u_pwm__232_/Y
+ sg13g2_a21oi_1
Xu_ppwm_u_mem__0991_ net487 VPWR u_ppwm_u_mem__0991_/Y VGND hold106/A net382 sg13g2_o21ai_1
XFILLER_30_969 VPWR VGND sg13g2_decap_8
XFILLER_6_631 VPWR VGND sg13g2_decap_8
Xu_ppwm_u_pwm__164_ u_ppwm_u_pwm__175_/A net625 u_ppwm_u_pwm__166_/B u_ppwm_u_pwm__240_/D
+ VPWR VGND sg13g2_nor3_1
XFILLER_1_391 VPWR VGND sg13g2_decap_8
XFILLER_49_362 VPWR VGND sg13g2_decap_8
XFILLER_37_546 VPWR VGND sg13g2_decap_8
XFILLER_18_760 VPWR VGND sg13g2_decap_8
XFILLER_17_292 VPWR VGND sg13g2_fill_1
XFILLER_33_774 VPWR VGND sg13g2_decap_8
XFILLER_21_925 VPWR VGND sg13g2_decap_8
XFILLER_32_273 VPWR VGND sg13g2_fill_1
Xu_ppwm_u_ex__0977_ u_ppwm_u_ex__0962_/Y VPWR u_ppwm_u_ex__0977_/Y VGND u_ppwm_u_ex__0965_/A
+ u_ppwm_u_ex__0963_/Y sg13g2_o21ai_1
Xu_ppwm_u_mem__1121__109 VPWR VGND net109 sg13g2_tiehi
Xheichips25_ppwm_23 VPWR VGND uo_out[4] sg13g2_tielo
Xheichips25_ppwm_12 VPWR VGND uio_out[0] sg13g2_tielo
XFILLER_28_546 VPWR VGND sg13g2_decap_8
XFILLER_43_505 VPWR VGND sg13g2_decap_8
Xu_ppwm_u_pwm__236__205 VPWR VGND net205 sg13g2_tiehi
XFILLER_11_402 VPWR VGND sg13g2_decap_4
XFILLER_12_947 VPWR VGND sg13g2_decap_8
XFILLER_23_273 VPWR VGND sg13g2_fill_2
XFILLER_24_796 VPWR VGND sg13g2_decap_8
XFILLER_23_32 VPWR VGND sg13g2_decap_8
XFILLER_23_54 VPWR VGND sg13g2_decap_4
XFILLER_7_417 VPWR VGND sg13g2_decap_4
XFILLER_11_479 VPWR VGND sg13g2_decap_8
XFILLER_3_623 VPWR VGND sg13g2_decap_8
XFILLER_2_111 VPWR VGND sg13g2_decap_8
XFILLER_24_1020 VPWR VGND sg13g2_decap_8
XFILLER_47_800 VPWR VGND sg13g2_decap_8
XFILLER_48_95 VPWR VGND sg13g2_decap_8
Xfanout481 net482 net481 VPWR VGND sg13g2_buf_8
Xfanout492 net493 net492 VPWR VGND sg13g2_buf_8
Xfanout470 net471 net470 VPWR VGND sg13g2_buf_2
XFILLER_0_14 VPWR VGND sg13g2_decap_8
XFILLER_19_557 VPWR VGND sg13g2_decap_8
Xu_ppwm_u_mem__1190_ net82 VGND VPWR net281 hold63/A clknet_5_25__leaf_clk sg13g2_dfrbpq_1
XFILLER_47_877 VPWR VGND sg13g2_decap_8
XFILLER_34_549 VPWR VGND sg13g2_decap_8
XFILLER_15_752 VPWR VGND sg13g2_decap_8
Xu_ppwm_u_ex__0900_ u_ppwm_u_ex__0901_/B u_ppwm_u_ex__0899_/Y u_ppwm_u_ex__0803_/A
+ u_ppwm_u_ex__0966_/B u_ppwm_u_ex__0804_/Y VPWR VGND sg13g2_a22oi_1
XFILLER_14_295 VPWR VGND sg13g2_decap_8
Xu_ppwm_u_ex__0831_ u_ppwm_u_ex__0832_/B net356 hold296/A net358 hold216/A VPWR VGND
+ sg13g2_a22oi_1
XFILLER_30_766 VPWR VGND sg13g2_decap_8
Xu_ppwm_u_ex__0762_ u_ppwm_u_ex__0761_/Y VPWR u_ppwm_u_ex__0762_/Y VGND u_ppwm_u_ex__0755_/Y
+ u_ppwm_u_ex__0759_/Y sg13g2_o21ai_1
Xu_ppwm_u_mem__0974_ VGND VPWR u_ppwm_u_mem__0645_/Y net389 hold103/A u_ppwm_u_mem__0973_/Y
+ sg13g2_a21oi_1
XFILLER_31_1013 VPWR VGND sg13g2_decap_8
Xu_ppwm_u_pwm__216_ u_ppwm_u_pwm__222_/A hold236/A hold70/A VPWR VGND sg13g2_nand2b_1
XFILLER_7_995 VPWR VGND sg13g2_decap_8
Xu_ppwm_u_pwm__147_ net476 VPWR u_ppwm_u_pwm__147_/Y VGND u_ppwm_u_pwm__154_/A net588
+ sg13g2_o21ai_1
Xu_ppwm_u_ex__0693_ u_ppwm_u_ex__0692_/Y VPWR u_ppwm_u_ex__0693_/Y VGND hold275/A
+ u_ppwm_u_ex__0721_/A sg13g2_o21ai_1
XFILLER_9_1025 VPWR VGND sg13g2_decap_4
Xu_ppwm_u_global_counter__165_ net56 VGND VPWR net653 hold268/A clknet_5_17__leaf_clk
+ sg13g2_dfrbpq_1
XFILLER_38_833 VPWR VGND sg13g2_decap_8
Xu_ppwm_u_global_counter__096_ VPWR u_ppwm_u_global_counter__096_/Y net608 VGND sg13g2_inv_1
XFILLER_21_722 VPWR VGND sg13g2_decap_8
Xu_ppwm_u_ex__1117__41 VPWR VGND net41 sg13g2_tiehi
XFILLER_33_571 VPWR VGND sg13g2_decap_8
XFILLER_21_799 VPWR VGND sg13g2_decap_8
XFILLER_0_637 VPWR VGND sg13g2_decap_8
XFILLER_29_822 VPWR VGND sg13g2_decap_8
XFILLER_44_803 VPWR VGND sg13g2_decap_8
XFILLER_29_899 VPWR VGND sg13g2_decap_8
XFILLER_16_527 VPWR VGND sg13g2_decap_8
XFILLER_12_744 VPWR VGND sg13g2_decap_8
XFILLER_24_593 VPWR VGND sg13g2_decap_8
XFILLER_11_254 VPWR VGND sg13g2_fill_2
XFILLER_8_759 VPWR VGND sg13g2_decap_8
Xu_ppwm_u_mem__0690_ VPWR u_ppwm_u_mem__0690_/Y net527 VGND sg13g2_inv_1
XFILLER_4_921 VPWR VGND sg13g2_decap_8
XFILLER_3_420 VPWR VGND sg13g2_decap_8
XFILLER_4_998 VPWR VGND sg13g2_decap_8
XFILLER_3_497 VPWR VGND sg13g2_decap_8
XFILLER_39_619 VPWR VGND sg13g2_decap_8
Xu_ppwm_u_ex__1030_ u_ppwm_u_ex__1030_/Y hold222/A fanout347/A VPWR VGND sg13g2_nand2_1
XFILLER_47_674 VPWR VGND sg13g2_decap_8
Xclkbuf_4_11_0_clk clknet_0_clk clknet_4_11_0_clk VPWR VGND sg13g2_buf_8
Xu_ppwm_u_mem__1173_ net76 VGND VPWR net340 hold122/A clknet_5_23__leaf_clk sg13g2_dfrbpq_1
XFILLER_35_814 VPWR VGND sg13g2_decap_8
XFILLER_30_563 VPWR VGND sg13g2_decap_8
Xu_ppwm_u_ex__0814_ net353 VPWR u_ppwm_u_ex__0815_/C VGND net375 u_ppwm_u_ex__0813_/Y
+ sg13g2_o21ai_1
Xu_ppwm_u_ex__0745_ u_ppwm_u_ex__0746_/B hold254/A u_ppwm_u_ex__0769_/A hold281/A
+ u_ppwm_u_ex__0571_/Y VPWR VGND sg13g2_a22oi_1
Xu_ppwm_u_mem__0957_ net488 VPWR u_ppwm_u_mem__0957_/Y VGND net237 net390 sg13g2_o21ai_1
XFILLER_7_792 VPWR VGND sg13g2_decap_8
Xu_ppwm_u_ex__0676_ u_ppwm_u_ex__0675_/Y VPWR u_ppwm_u_ex__0676_/Y VGND hold271/A
+ u_ppwm_u_ex__0600_/Y sg13g2_o21ai_1
Xu_ppwm_u_mem__0888_ VGND VPWR u_ppwm_u_mem__0688_/Y net398 u_ppwm_u_mem__1114_/D
+ u_ppwm_u_mem__0887_/Y sg13g2_a21oi_1
Xu_ppwm_u_mem__1204__78 VPWR VGND net78 sg13g2_tiehi
XFILLER_41_0 VPWR VGND sg13g2_decap_8
XFILLER_38_630 VPWR VGND sg13g2_decap_8
Xu_ppwm_u_global_counter__148_ net650 u_ppwm_u_global_counter__148_/B u_ppwm_u_global_counter__175_/D
+ VPWR VGND sg13g2_nor2_1
XFILLER_26_858 VPWR VGND sg13g2_decap_8
XFILLER_38_1008 VPWR VGND sg13g2_decap_8
XFILLER_41_839 VPWR VGND sg13g2_decap_8
XFILLER_21_596 VPWR VGND sg13g2_decap_8
XFILLER_1_902 VPWR VGND sg13g2_decap_8
XFILLER_0_434 VPWR VGND sg13g2_decap_8
XFILLER_1_979 VPWR VGND sg13g2_decap_8
Xhold20 hold20/A VPWR VGND net237 sg13g2_dlygate4sd3_1
Xhold31 hold31/A VPWR VGND net248 sg13g2_dlygate4sd3_1
Xhold53 hold53/A VPWR VGND net270 sg13g2_dlygate4sd3_1
Xhold42 hold42/A VPWR VGND net259 sg13g2_dlygate4sd3_1
Xhold64 hold64/A VPWR VGND net281 sg13g2_dlygate4sd3_1
Xhold97 hold97/A VPWR VGND net314 sg13g2_dlygate4sd3_1
Xhold75 hold75/A VPWR VGND net292 sg13g2_dlygate4sd3_1
Xhold86 hold86/A VPWR VGND net303 sg13g2_dlygate4sd3_1
XFILLER_21_1023 VPWR VGND sg13g2_decap_4
XFILLER_44_600 VPWR VGND sg13g2_decap_8
XFILLER_16_324 VPWR VGND sg13g2_fill_1
XFILLER_17_825 VPWR VGND sg13g2_decap_8
XFILLER_29_696 VPWR VGND sg13g2_decap_8
XFILLER_45_74 VPWR VGND sg13g2_fill_1
XFILLER_28_195 VPWR VGND sg13g2_fill_2
XFILLER_44_677 VPWR VGND sg13g2_decap_8
Xu_ppwm_u_mem__1110__130 VPWR VGND net130 sg13g2_tiehi
XFILLER_43_176 VPWR VGND sg13g2_fill_2
XFILLER_12_541 VPWR VGND sg13g2_decap_8
Xu_ppwm_u_mem__0811_ hold88/A hold186/A net464 u_ppwm_u_mem__0811_/X VPWR VGND sg13g2_mux2_1
XFILLER_8_556 VPWR VGND sg13g2_decap_8
Xu_ppwm_u_mem__0742_ hold119/A net466 u_ppwm_u_mem__0742_/Y VPWR VGND sg13g2_nor2b_1
Xu_ppwm_u_mem__0673_ VPWR u_ppwm_u_mem__0673_/Y net558 VGND sg13g2_inv_1
XFILLER_4_795 VPWR VGND sg13g2_decap_8
XFILLER_39_438 VPWR VGND sg13g2_decap_4
XFILLER_13_4 VPWR VGND sg13g2_decap_8
XFILLER_48_961 VPWR VGND sg13g2_decap_8
Xu_ppwm_u_ex__1013_ u_ppwm_u_ex__1005_/Y VPWR u_ppwm_u_ex__1016_/A VGND u_ppwm_u_ex__0996_/Y
+ u_ppwm_u_ex__1006_/Y sg13g2_o21ai_1
XFILLER_47_471 VPWR VGND sg13g2_decap_8
XFILLER_35_611 VPWR VGND sg13g2_decap_8
Xu_ppwm_u_mem__1156_ net143 VGND VPWR u_ppwm_u_mem__1156_/D hold148/A clknet_5_13__leaf_clk
+ sg13g2_dfrbpq_2
Xu_ppwm_u_mem__1087_ VPWR VGND u_ppwm_u_mem__1086_/Y u_ppwm_u_mem__1081_/A u_ppwm_u_mem__1077_/S
+ u_ppwm_u_mem__0833_/A hold228/A u_ppwm_u_mem__1075_/B sg13g2_a221oi_1
XFILLER_35_688 VPWR VGND sg13g2_decap_8
XFILLER_16_891 VPWR VGND sg13g2_decap_8
XFILLER_31_894 VPWR VGND sg13g2_decap_8
Xu_ppwm_u_ex__0728_ net357 u_ppwm_u_ex__0728_/C u_ppwm_u_ex__0728_/A u_ppwm_u_ex__0776_/B
+ VPWR VGND sg13g2_nand3_1
Xu_ppwm_u_ex__0659_ net446 u_ppwm_u_ex__0751_/B u_ppwm_u_ex__0659_/Y VPWR VGND sg13g2_nor2_1
XFILLER_46_909 VPWR VGND sg13g2_decap_8
Xu_ppwm_u_mem__1092__166 VPWR VGND net166 sg13g2_tiehi
XFILLER_39_983 VPWR VGND sg13g2_decap_8
XFILLER_25_132 VPWR VGND sg13g2_fill_2
XFILLER_26_655 VPWR VGND sg13g2_decap_8
XFILLER_14_828 VPWR VGND sg13g2_decap_8
XFILLER_15_11 VPWR VGND sg13g2_decap_8
XFILLER_41_636 VPWR VGND sg13g2_decap_8
XFILLER_13_338 VPWR VGND sg13g2_fill_2
XFILLER_22_861 VPWR VGND sg13g2_decap_8
Xu_ppwm_u_global_counter__166__74 VPWR VGND net74 sg13g2_tiehi
XFILLER_5_559 VPWR VGND sg13g2_decap_8
Xu_ppwm_u_mem__1140__189 VPWR VGND net189 sg13g2_tiehi
XFILLER_1_776 VPWR VGND sg13g2_decap_8
XFILLER_49_747 VPWR VGND sg13g2_decap_8
XFILLER_0_275 VPWR VGND sg13g2_decap_8
XFILLER_17_622 VPWR VGND sg13g2_decap_8
XFILLER_45_942 VPWR VGND sg13g2_decap_8
XFILLER_29_493 VPWR VGND sg13g2_decap_8
Xu_ppwm_u_mem__1010_ VGND VPWR u_ppwm_u_mem__0627_/Y net417 hold85/A u_ppwm_u_mem__1009_/Y
+ sg13g2_a21oi_1
XFILLER_44_474 VPWR VGND sg13g2_decap_8
XFILLER_16_165 VPWR VGND sg13g2_fill_2
XFILLER_17_699 VPWR VGND sg13g2_decap_8
XFILLER_16_176 VPWR VGND sg13g2_decap_4
XFILLER_13_861 VPWR VGND sg13g2_decap_8
XFILLER_32_669 VPWR VGND sg13g2_decap_8
XFILLER_9_843 VPWR VGND sg13g2_decap_8
XFILLER_8_386 VPWR VGND sg13g2_fill_2
Xu_ppwm_u_mem__0725_ VGND VPWR u_ppwm_u_mem__0723_/Y u_ppwm_u_mem__0724_/Y u_ppwm_u_mem__0725_/Y
+ net458 sg13g2_a21oi_1
XFILLER_4_592 VPWR VGND sg13g2_decap_8
Xu_ppwm_u_mem__0656_ VPWR u_ppwm_u_mem__0656_/Y net557 VGND sg13g2_inv_1
Xu_ppwm_u_mem__1208_ net484 VGND VPWR net1 hold2/A clknet_5_8__leaf_clk sg13g2_dfrbpq_1
XFILLER_36_942 VPWR VGND sg13g2_decap_8
Xu_ppwm_u_mem__1139_ net191 VGND VPWR u_ppwm_u_mem__1139_/D hold48/A clknet_5_28__leaf_clk
+ sg13g2_dfrbpq_1
XFILLER_35_452 VPWR VGND sg13g2_fill_1
XFILLER_35_485 VPWR VGND sg13g2_decap_8
XFILLER_23_658 VPWR VGND sg13g2_decap_8
XFILLER_31_691 VPWR VGND sg13g2_decap_8
XFILLER_11_1011 VPWR VGND sg13g2_decap_8
XFILLER_2_529 VPWR VGND sg13g2_decap_8
XFILLER_46_706 VPWR VGND sg13g2_decap_8
XFILLER_18_408 VPWR VGND sg13g2_fill_1
XFILLER_39_780 VPWR VGND sg13g2_decap_8
Xclkbuf_5_23__f_clk clknet_4_11_0_clk clknet_5_23__leaf_clk VPWR VGND sg13g2_buf_8
XFILLER_27_953 VPWR VGND sg13g2_decap_8
XFILLER_42_923 VPWR VGND sg13g2_decap_8
XFILLER_26_54 VPWR VGND sg13g2_fill_1
XFILLER_26_452 VPWR VGND sg13g2_decap_8
XFILLER_41_422 VPWR VGND sg13g2_fill_2
XFILLER_14_625 VPWR VGND sg13g2_decap_8
XFILLER_26_98 VPWR VGND sg13g2_fill_2
Xu_ppwm_u_pwm__180_ net478 VPWR u_ppwm_u_pwm__180_/Y VGND net450 net378 sg13g2_o21ai_1
XFILLER_10_831 VPWR VGND sg13g2_decap_8
XFILLER_6_813 VPWR VGND sg13g2_decap_8
XFILLER_3_47 VPWR VGND sg13g2_fill_1
XFILLER_1_573 VPWR VGND sg13g2_decap_8
XFILLER_49_544 VPWR VGND sg13g2_decap_8
XFILLER_37_728 VPWR VGND sg13g2_decap_8
XFILLER_18_942 VPWR VGND sg13g2_decap_8
XFILLER_36_227 VPWR VGND sg13g2_decap_8
XFILLER_17_496 VPWR VGND sg13g2_decap_8
XFILLER_33_956 VPWR VGND sg13g2_decap_8
Xu_ppwm_u_ex__0993_ net369 u_ppwm_u_ex__0993_/B net353 u_ppwm_u_ex__0993_/Y VPWR VGND
+ sg13g2_nor3_1
XFILLER_34_1011 VPWR VGND sg13g2_decap_8
XFILLER_9_640 VPWR VGND sg13g2_decap_8
Xu_ppwm_u_mem__0708_ VPWR u_ppwm_u_mem__0708_/Y net332 VGND sg13g2_inv_1
Xu_ppwm_u_mem__0639_ VPWR u_ppwm_u_mem__0639_/Y net252 VGND sg13g2_inv_1
XFILLER_28_728 VPWR VGND sg13g2_decap_8
XFILLER_24_901 VPWR VGND sg13g2_decap_8
XFILLER_23_455 VPWR VGND sg13g2_decap_8
XFILLER_24_978 VPWR VGND sg13g2_decap_8
XFILLER_12_67 VPWR VGND sg13g2_fill_2
XFILLER_3_805 VPWR VGND sg13g2_decap_8
Xhold161 hold161/A VPWR VGND net544 sg13g2_dlygate4sd3_1
Xhold150 hold150/A VPWR VGND net533 sg13g2_dlygate4sd3_1
Xhold194 hold194/A VPWR VGND net577 sg13g2_dlygate4sd3_1
Xhold183 hold183/A VPWR VGND net566 sg13g2_dlygate4sd3_1
Xhold172 hold172/A VPWR VGND net555 sg13g2_dlygate4sd3_1
XFILLER_46_503 VPWR VGND sg13g2_decap_8
Xu_ppwm_u_mem__1139__191 VPWR VGND net191 sg13g2_tiehi
XFILLER_19_739 VPWR VGND sg13g2_decap_8
XFILLER_27_750 VPWR VGND sg13g2_decap_8
XFILLER_42_720 VPWR VGND sg13g2_decap_8
XFILLER_15_934 VPWR VGND sg13g2_decap_8
XFILLER_18_1028 VPWR VGND sg13g2_fill_1
XFILLER_26_293 VPWR VGND sg13g2_fill_1
XFILLER_42_797 VPWR VGND sg13g2_decap_8
Xu_ppwm_u_pwm__252__200 VPWR VGND net200 sg13g2_tiehi
XFILLER_14_499 VPWR VGND sg13g2_decap_8
XFILLER_30_948 VPWR VGND sg13g2_decap_8
XFILLER_41_296 VPWR VGND sg13g2_fill_1
Xu_ppwm_u_pwm__232_ net479 VPWR u_ppwm_u_pwm__232_/Y VGND net225 u_ppwm_u_pwm__231_/Y
+ sg13g2_o21ai_1
Xu_ppwm_u_mem__0990_ VGND VPWR u_ppwm_u_mem__0637_/Y net387 u_ppwm_u_mem__1165_/D
+ u_ppwm_u_mem__0989_/Y sg13g2_a21oi_1
XFILLER_6_610 VPWR VGND sg13g2_decap_8
Xu_ppwm_u_pwm__163_ net624 u_ppwm_u_pwm__163_/B u_ppwm_u_pwm__166_/B VPWR VGND sg13g2_and2_1
XFILLER_6_687 VPWR VGND sg13g2_decap_8
XFILLER_45_7 VPWR VGND sg13g2_fill_1
XFILLER_2_893 VPWR VGND sg13g2_decap_8
XFILLER_1_370 VPWR VGND sg13g2_decap_8
XFILLER_49_341 VPWR VGND sg13g2_decap_8
XFILLER_37_525 VPWR VGND sg13g2_decap_8
Xu_ppwm_u_mem__1153__155 VPWR VGND net155 sg13g2_tiehi
XFILLER_17_282 VPWR VGND sg13g2_fill_1
XFILLER_21_904 VPWR VGND sg13g2_decap_8
XFILLER_33_753 VPWR VGND sg13g2_decap_8
Xu_ppwm_u_ex__0976_ u_ppwm_u_ex__0976_/A u_ppwm_u_ex__0976_/B u_ppwm_u_ex__1130_/D
+ VPWR VGND sg13g2_nor2_1
XFILLER_32_285 VPWR VGND sg13g2_decap_4
XFILLER_0_819 VPWR VGND sg13g2_decap_8
Xheichips25_ppwm_24 VPWR VGND uo_out[5] sg13g2_tielo
Xheichips25_ppwm_13 VPWR VGND uio_out[1] sg13g2_tielo
XFILLER_28_525 VPWR VGND sg13g2_decap_8
XFILLER_16_709 VPWR VGND sg13g2_decap_8
XFILLER_12_926 VPWR VGND sg13g2_decap_8
XFILLER_23_11 VPWR VGND sg13g2_decap_8
XFILLER_23_263 VPWR VGND sg13g2_fill_1
XFILLER_24_775 VPWR VGND sg13g2_decap_8
XFILLER_3_602 VPWR VGND sg13g2_decap_8
XFILLER_3_679 VPWR VGND sg13g2_decap_8
XFILLER_48_74 VPWR VGND sg13g2_decap_8
Xfanout471 net473 net471 VPWR VGND sg13g2_buf_8
Xfanout482 net493 net482 VPWR VGND sg13g2_buf_8
Xfanout493 rst_n net493 VPWR VGND sg13g2_buf_8
Xfanout460 net461 net460 VPWR VGND sg13g2_buf_8
XFILLER_47_856 VPWR VGND sg13g2_decap_8
XFILLER_19_536 VPWR VGND sg13g2_decap_8
XFILLER_34_528 VPWR VGND sg13g2_decap_8
XFILLER_15_731 VPWR VGND sg13g2_decap_8
XFILLER_14_241 VPWR VGND sg13g2_fill_1
XFILLER_42_594 VPWR VGND sg13g2_decap_8
Xu_ppwm_u_ex__0830_ u_ppwm_u_ex__1009_/A net371 u_ppwm_u_ex__0860_/B VPWR VGND sg13g2_nand2_1
XFILLER_30_745 VPWR VGND sg13g2_decap_8
Xu_ppwm_u_mem__1183__137 VPWR VGND net137 sg13g2_tiehi
Xu_ppwm_u_ex__0761_ VGND VPWR u_ppwm_u_ex__0573_/Y net426 u_ppwm_u_ex__0761_/Y u_ppwm_u_ex__0760_/Y
+ sg13g2_a21oi_1
Xu_ppwm_u_mem__0973_ net488 VPWR u_ppwm_u_mem__0973_/Y VGND hold194/A net389 sg13g2_o21ai_1
Xu_ppwm_u_pwm__215_ u_ppwm_u_pwm__208_/Y VPWR u_ppwm_u_pwm__215_/Y VGND u_ppwm_u_pwm__212_/Y
+ u_ppwm_u_pwm__214_/X sg13g2_o21ai_1
XFILLER_7_974 VPWR VGND sg13g2_decap_8
Xu_ppwm_u_pwm__146_ u_ppwm_u_pwm__146_/A u_ppwm_u_pwm__146_/B net572 u_ppwm_u_pwm__146_/D
+ hold190/A VPWR VGND sg13g2_nor4_1
Xu_ppwm_u_ex__0692_ u_ppwm_u_ex__0692_/Y net442 net432 VPWR VGND sg13g2_nand2b_1
XFILLER_6_484 VPWR VGND sg13g2_decap_8
XFILLER_9_1004 VPWR VGND sg13g2_decap_8
XFILLER_2_690 VPWR VGND sg13g2_decap_8
XFILLER_38_812 VPWR VGND sg13g2_decap_8
Xu_ppwm_u_global_counter__164_ net58 VGND VPWR u_ppwm_u_global_counter__164_/D hold279/A
+ clknet_5_20__leaf_clk sg13g2_dfrbpq_2
Xu_ppwm_u_global_counter__095_ VPWR u_ppwm_u_global_counter__141_/C net679 VGND sg13g2_inv_1
XFILLER_38_889 VPWR VGND sg13g2_decap_8
XFILLER_21_701 VPWR VGND sg13g2_decap_8
XFILLER_33_550 VPWR VGND sg13g2_decap_8
XFILLER_20_211 VPWR VGND sg13g2_fill_2
XFILLER_21_778 VPWR VGND sg13g2_decap_8
Xu_ppwm_u_ex__0959_ net362 VPWR u_ppwm_u_ex__0960_/B VGND hold276/A net442 sg13g2_o21ai_1
XFILLER_47_1010 VPWR VGND sg13g2_decap_8
XFILLER_0_616 VPWR VGND sg13g2_decap_8
XFILLER_29_801 VPWR VGND sg13g2_decap_8
XFILLER_18_33 VPWR VGND sg13g2_fill_2
XFILLER_28_322 VPWR VGND sg13g2_fill_1
XFILLER_16_506 VPWR VGND sg13g2_decap_8
XFILLER_29_878 VPWR VGND sg13g2_decap_8
XFILLER_44_859 VPWR VGND sg13g2_decap_8
XFILLER_24_572 VPWR VGND sg13g2_decap_8
XFILLER_31_509 VPWR VGND sg13g2_decap_8
XFILLER_12_723 VPWR VGND sg13g2_decap_8
XFILLER_8_738 VPWR VGND sg13g2_decap_8
XFILLER_11_277 VPWR VGND sg13g2_decap_4
XFILLER_4_900 VPWR VGND sg13g2_decap_8
XFILLER_4_977 VPWR VGND sg13g2_decap_8
XFILLER_3_476 VPWR VGND sg13g2_decap_8
XFILLER_1_0 VPWR VGND sg13g2_decap_8
XFILLER_19_322 VPWR VGND sg13g2_fill_2
XFILLER_47_653 VPWR VGND sg13g2_decap_8
XFILLER_46_141 VPWR VGND sg13g2_fill_2
Xu_ppwm_u_mem__1172_ net80 VGND VPWR u_ppwm_u_mem__1172_/D hold209/A clknet_5_22__leaf_clk
+ sg13g2_dfrbpq_2
XFILLER_34_314 VPWR VGND sg13g2_fill_2
Xu_ppwm_u_ex__0813_ VPWR u_ppwm_u_ex__0813_/Y u_ppwm_u_ex__0813_/A VGND sg13g2_inv_1
XFILLER_30_542 VPWR VGND sg13g2_decap_8
Xu_ppwm_u_ex__0744_ hold256/A u_ppwm_u_ex__0744_/C u_ppwm_u_ex__0746_/A VPWR VGND
+ net432 sg13g2_nand3b_1
Xu_ppwm_u_mem__0956_ VGND VPWR u_ppwm_u_mem__0654_/Y net392 hold139/A u_ppwm_u_mem__0955_/Y
+ sg13g2_a21oi_1
XFILLER_7_771 VPWR VGND sg13g2_decap_8
Xu_ppwm_u_ex__0675_ net376 net374 net369 u_ppwm_u_ex__0675_/Y VPWR VGND sg13g2_nor3_1
Xu_ppwm_u_mem__0887_ net489 VPWR u_ppwm_u_mem__0887_/Y VGND net304 net398 sg13g2_o21ai_1
Xu_ppwm_u_pwm__129_ VPWR u_ppwm_u_pwm__200_/A net586 VGND sg13g2_inv_1
XFILLER_34_0 VPWR VGND sg13g2_decap_8
XFILLER_29_119 VPWR VGND sg13g2_fill_2
Xclkbuf_5_4__f_clk clknet_4_2_0_clk clknet_5_4__leaf_clk VPWR VGND sg13g2_buf_8
Xu_ppwm_u_global_counter__147_ u_ppwm_u_global_counter__148_/B net480 u_ppwm_u_global_counter__147_/B
+ VPWR VGND sg13g2_nand2_1
XFILLER_26_837 VPWR VGND sg13g2_decap_8
XFILLER_37_174 VPWR VGND sg13g2_decap_4
XFILLER_38_686 VPWR VGND sg13g2_decap_8
Xu_ppwm_u_ex__1089_ net364 VPWR u_ppwm_u_ex__1090_/B VGND hold275/A net432 sg13g2_o21ai_1
XFILLER_41_818 VPWR VGND sg13g2_decap_8
XFILLER_40_306 VPWR VGND sg13g2_fill_1
XFILLER_33_391 VPWR VGND sg13g2_fill_1
XFILLER_34_892 VPWR VGND sg13g2_decap_8
XFILLER_21_575 VPWR VGND sg13g2_decap_8
XFILLER_4_218 VPWR VGND sg13g2_fill_2
Xu_ppwm_u_mem__1207__195 VPWR VGND net195 sg13g2_tiehi
XFILLER_0_413 VPWR VGND sg13g2_decap_8
XFILLER_1_958 VPWR VGND sg13g2_decap_8
XFILLER_49_929 VPWR VGND sg13g2_decap_8
Xhold10 hold10/A VPWR VGND net227 sg13g2_dlygate4sd3_1
Xhold32 hold32/A VPWR VGND net249 sg13g2_dlygate4sd3_1
Xhold21 hold21/A VPWR VGND net238 sg13g2_dlygate4sd3_1
Xhold54 hold54/A VPWR VGND net271 sg13g2_dlygate4sd3_1
XFILLER_21_1002 VPWR VGND sg13g2_decap_8
Xhold65 hold65/A VPWR VGND net282 sg13g2_dlygate4sd3_1
XFILLER_29_87 VPWR VGND sg13g2_fill_1
Xhold43 hold43/A VPWR VGND net260 sg13g2_dlygate4sd3_1
Xhold76 hold76/A VPWR VGND net293 sg13g2_dlygate4sd3_1
XFILLER_17_804 VPWR VGND sg13g2_decap_8
Xhold98 hold98/A VPWR VGND net315 sg13g2_dlygate4sd3_1
Xhold87 hold87/A VPWR VGND net304 sg13g2_dlygate4sd3_1
XFILLER_29_675 VPWR VGND sg13g2_decap_8
XFILLER_44_656 VPWR VGND sg13g2_decap_8
XFILLER_28_185 VPWR VGND sg13g2_fill_2
Xu_ppwm_u_mem__1131__89 VPWR VGND net89 sg13g2_tiehi
XFILLER_12_520 VPWR VGND sg13g2_decap_8
XFILLER_40_884 VPWR VGND sg13g2_decap_8
XFILLER_8_535 VPWR VGND sg13g2_decap_8
XFILLER_12_597 VPWR VGND sg13g2_decap_8
Xu_ppwm_u_mem__0810_ hold61/A hold173/A net463 u_ppwm_u_mem__0810_/X VPWR VGND sg13g2_mux2_1
Xu_ppwm_u_mem__0741_ VGND VPWR u_ppwm_u_mem__0739_/Y u_ppwm_u_mem__0740_/Y u_ppwm_u_mem__0741_/Y
+ net459 sg13g2_a21oi_1
Xu_ppwm_u_mem__0672_ VPWR u_ppwm_u_mem__0672_/Y net317 VGND sg13g2_inv_1
Xu_ppwm_u_pwm__249__216 VPWR VGND net216 sg13g2_tiehi
XFILLER_4_774 VPWR VGND sg13g2_decap_8
XFILLER_3_273 VPWR VGND sg13g2_fill_1
XFILLER_39_417 VPWR VGND sg13g2_decap_8
XFILLER_48_940 VPWR VGND sg13g2_decap_8
XFILLER_0_980 VPWR VGND sg13g2_decap_8
XFILLER_47_450 VPWR VGND sg13g2_decap_8
Xu_ppwm_u_ex__1012_ u_ppwm_u_ex__1012_/A u_ppwm_u_ex__1012_/B hold300/A VPWR VGND
+ sg13g2_nor2_1
XFILLER_19_152 VPWR VGND sg13g2_fill_2
Xu_ppwm_u_mem__1155_ net147 VGND VPWR u_ppwm_u_mem__1155_/D hold182/A clknet_5_12__leaf_clk
+ sg13g2_dfrbpq_1
XFILLER_16_870 VPWR VGND sg13g2_decap_8
Xu_ppwm_u_mem__1086_ hold248/A u_ppwm_u_mem__1086_/B u_ppwm_u_mem__1086_/Y VPWR VGND
+ sg13g2_nor2_1
XFILLER_34_166 VPWR VGND sg13g2_fill_2
XFILLER_35_667 VPWR VGND sg13g2_decap_8
XFILLER_15_380 VPWR VGND sg13g2_fill_2
XFILLER_31_873 VPWR VGND sg13g2_decap_8
Xu_ppwm_u_mem__0939_ net501 VPWR u_ppwm_u_mem__0939_/Y VGND net233 net414 sg13g2_o21ai_1
Xu_ppwm_u_ex__0727_ u_ppwm_u_ex__0728_/C u_ppwm_u_ex__0727_/A u_ppwm_u_ex__0727_/B
+ VPWR VGND sg13g2_nand2_1
Xu_ppwm_u_ex__0658_ u_ppwm_u_ex__0658_/A hold288/A u_ppwm_u_ex__0658_/Y VPWR VGND
+ sg13g2_nor2_1
XFILLER_44_1013 VPWR VGND sg13g2_decap_8
Xu_ppwm_u_ex__0589_ VPWR u_ppwm_u_ex__0789_/A u_ppwm/instr\[0\] VGND sg13g2_inv_1
XFILLER_39_962 VPWR VGND sg13g2_decap_8
XFILLER_38_483 VPWR VGND sg13g2_decap_8
XFILLER_26_634 VPWR VGND sg13g2_decap_8
XFILLER_41_615 VPWR VGND sg13g2_decap_8
XFILLER_14_807 VPWR VGND sg13g2_decap_8
XFILLER_25_144 VPWR VGND sg13g2_fill_2
XFILLER_22_840 VPWR VGND sg13g2_decap_8
XFILLER_5_538 VPWR VGND sg13g2_decap_8
Xclkbuf_4_10_0_clk clknet_0_clk clknet_4_10_0_clk VPWR VGND sg13g2_buf_8
XFILLER_1_755 VPWR VGND sg13g2_decap_8
XFILLER_49_726 VPWR VGND sg13g2_decap_8
XFILLER_45_921 VPWR VGND sg13g2_decap_8
XFILLER_17_601 VPWR VGND sg13g2_decap_8
XFILLER_45_998 VPWR VGND sg13g2_decap_8
XFILLER_44_453 VPWR VGND sg13g2_decap_8
XFILLER_17_678 VPWR VGND sg13g2_decap_8
XFILLER_16_188 VPWR VGND sg13g2_fill_2
XFILLER_32_648 VPWR VGND sg13g2_decap_8
XFILLER_13_840 VPWR VGND sg13g2_decap_8
XFILLER_40_681 VPWR VGND sg13g2_decap_8
XFILLER_9_822 VPWR VGND sg13g2_decap_8
Xu_ppwm_u_mem__1149__171 VPWR VGND net171 sg13g2_tiehi
XFILLER_8_343 VPWR VGND sg13g2_fill_1
XFILLER_8_332 VPWR VGND sg13g2_decap_8
XFILLER_9_899 VPWR VGND sg13g2_decap_8
Xu_ppwm_u_mem__0724_ u_ppwm_u_mem__0724_/Y hold209/A net467 VPWR VGND sg13g2_nand2b_1
XFILLER_28_1008 VPWR VGND sg13g2_decap_8
XFILLER_4_571 VPWR VGND sg13g2_decap_8
Xu_ppwm_u_mem__0655_ VPWR u_ppwm_u_mem__0655_/Y net554 VGND sg13g2_inv_1
XFILLER_39_236 VPWR VGND sg13g2_fill_2
XFILLER_36_921 VPWR VGND sg13g2_decap_8
Xu_ppwm_u_mem__1207_ net195 VGND VPWR net611 hold227/A clknet_5_3__leaf_clk sg13g2_dfrbpq_2
Xu_ppwm_u_mem__1138_ net193 VGND VPWR u_ppwm_u_mem__1138_/D hold66/A clknet_5_31__leaf_clk
+ sg13g2_dfrbpq_1
Xheichips25_ppwm_4 VPWR VGND uio_oe[0] sg13g2_tielo
XFILLER_36_998 VPWR VGND sg13g2_decap_8
XFILLER_23_637 VPWR VGND sg13g2_decap_8
Xu_ppwm_u_mem__1069_ u_ppwm_u_mem__1081_/A u_ppwm_u_mem__1069_/B net312 hold96/A VPWR
+ VGND sg13g2_nor3_1
XFILLER_31_670 VPWR VGND sg13g2_decap_8
XFILLER_30_191 VPWR VGND sg13g2_fill_1
XFILLER_2_508 VPWR VGND sg13g2_decap_8
XFILLER_26_11 VPWR VGND sg13g2_decap_8
XFILLER_26_431 VPWR VGND sg13g2_decap_8
XFILLER_27_932 VPWR VGND sg13g2_decap_8
XFILLER_42_902 VPWR VGND sg13g2_decap_8
XFILLER_14_604 VPWR VGND sg13g2_decap_8
XFILLER_42_979 VPWR VGND sg13g2_decap_8
XFILLER_41_489 VPWR VGND sg13g2_decap_8
XFILLER_10_810 VPWR VGND sg13g2_decap_8
XFILLER_10_887 VPWR VGND sg13g2_decap_8
XFILLER_6_869 VPWR VGND sg13g2_decap_8
XFILLER_1_552 VPWR VGND sg13g2_decap_8
XFILLER_49_523 VPWR VGND sg13g2_decap_8
XFILLER_37_707 VPWR VGND sg13g2_decap_8
XFILLER_18_921 VPWR VGND sg13g2_decap_8
XFILLER_44_250 VPWR VGND sg13g2_decap_4
XFILLER_45_795 VPWR VGND sg13g2_decap_8
XFILLER_17_475 VPWR VGND sg13g2_decap_8
XFILLER_18_998 VPWR VGND sg13g2_decap_8
XFILLER_33_935 VPWR VGND sg13g2_decap_8
Xu_ppwm_u_ex__0992_ VGND VPWR u_ppwm_u_ex__0990_/Y u_ppwm_u_ex__0991_/Y u_ppwm_u_ex__0992_/Y
+ net352 sg13g2_a21oi_1
XFILLER_20_629 VPWR VGND sg13g2_decap_8
XFILLER_12_180 VPWR VGND sg13g2_fill_2
XFILLER_9_696 VPWR VGND sg13g2_decap_8
Xu_ppwm_u_mem__0707_ VPWR u_ppwm_u_mem__0707_/Y net335 VGND sg13g2_inv_1
Xu_ppwm_u_mem__0638_ VPWR u_ppwm_u_mem__0638_/Y net568 VGND sg13g2_inv_1
XFILLER_28_707 VPWR VGND sg13g2_decap_8
XFILLER_36_795 VPWR VGND sg13g2_decap_8
XFILLER_23_434 VPWR VGND sg13g2_decap_8
XFILLER_24_957 VPWR VGND sg13g2_decap_8
Xhold140 hold140/A VPWR VGND net523 sg13g2_dlygate4sd3_1
Xhold151 hold151/A VPWR VGND net534 sg13g2_dlygate4sd3_1
Xhold162 hold162/A VPWR VGND net545 sg13g2_dlygate4sd3_1
Xhold195 hold195/A VPWR VGND net578 sg13g2_dlygate4sd3_1
Xhold184 hold184/A VPWR VGND net567 sg13g2_dlygate4sd3_1
Xhold173 hold173/A VPWR VGND net556 sg13g2_dlygate4sd3_1
XFILLER_19_718 VPWR VGND sg13g2_decap_8
XFILLER_37_21 VPWR VGND sg13g2_decap_8
XFILLER_46_559 VPWR VGND sg13g2_decap_8
XFILLER_37_65 VPWR VGND sg13g2_fill_1
XFILLER_15_913 VPWR VGND sg13g2_decap_8
XFILLER_37_98 VPWR VGND sg13g2_decap_8
XFILLER_14_412 VPWR VGND sg13g2_decap_4
XFILLER_26_283 VPWR VGND sg13g2_fill_2
XFILLER_42_776 VPWR VGND sg13g2_decap_8
XFILLER_14_478 VPWR VGND sg13g2_decap_8
XFILLER_30_927 VPWR VGND sg13g2_decap_8
Xu_ppwm_u_pwm__231_ u_ppwm_u_pwm__203_/Y VPWR u_ppwm_u_pwm__231_/Y VGND u_ppwm_u_pwm__228_/Y
+ u_ppwm_u_pwm__230_/X sg13g2_o21ai_1
Xu_ppwm_u_mem__1107__136 VPWR VGND net136 sg13g2_tiehi
Xu_ppwm_u_pwm__162_ net624 u_ppwm_u_pwm__163_/B hold242/A VPWR VGND sg13g2_nor2_1
XFILLER_10_684 VPWR VGND sg13g2_decap_8
XFILLER_6_666 VPWR VGND sg13g2_decap_8
XFILLER_2_872 VPWR VGND sg13g2_decap_8
XFILLER_38_7 VPWR VGND sg13g2_decap_8
XFILLER_37_504 VPWR VGND sg13g2_decap_8
XFILLER_49_397 VPWR VGND sg13g2_decap_8
XFILLER_17_250 VPWR VGND sg13g2_decap_8
XFILLER_17_261 VPWR VGND sg13g2_fill_1
XFILLER_18_795 VPWR VGND sg13g2_decap_8
XFILLER_45_592 VPWR VGND sg13g2_decap_8
XFILLER_33_732 VPWR VGND sg13g2_decap_8
Xu_ppwm_u_ex__0975_ net481 VPWR u_ppwm_u_ex__0976_/B VGND net441 net344 sg13g2_o21ai_1
XFILLER_9_493 VPWR VGND sg13g2_decap_8
Xu_ppwm_u_mem__1160__127 VPWR VGND net127 sg13g2_tiehi
Xheichips25_ppwm_25 VPWR VGND uo_out[6] sg13g2_tielo
Xheichips25_ppwm_14 VPWR VGND uio_out[2] sg13g2_tielo
XFILLER_28_504 VPWR VGND sg13g2_decap_8
XFILLER_12_905 VPWR VGND sg13g2_decap_8
XFILLER_23_231 VPWR VGND sg13g2_decap_8
XFILLER_24_754 VPWR VGND sg13g2_decap_8
XFILLER_36_592 VPWR VGND sg13g2_decap_8
XFILLER_11_448 VPWR VGND sg13g2_fill_2
XFILLER_23_275 VPWR VGND sg13g2_fill_1
XFILLER_23_297 VPWR VGND sg13g2_decap_4
XFILLER_20_993 VPWR VGND sg13g2_decap_8
XFILLER_3_658 VPWR VGND sg13g2_decap_8
XFILLER_3_4 VPWR VGND sg13g2_decap_8
XFILLER_2_146 VPWR VGND sg13g2_fill_1
Xfanout450 net660 net450 VPWR VGND sg13g2_buf_8
Xfanout472 net473 net472 VPWR VGND sg13g2_buf_8
XFILLER_19_515 VPWR VGND sg13g2_decap_8
Xfanout483 net484 net483 VPWR VGND sg13g2_buf_8
Xfanout461 net462 net461 VPWR VGND sg13g2_buf_8
XFILLER_47_835 VPWR VGND sg13g2_decap_8
Xfanout494 net497 net494 VPWR VGND sg13g2_buf_8
XFILLER_0_49 VPWR VGND sg13g2_decap_8
XFILLER_34_507 VPWR VGND sg13g2_decap_8
XFILLER_15_710 VPWR VGND sg13g2_decap_8
XFILLER_42_573 VPWR VGND sg13g2_decap_8
XFILLER_14_264 VPWR VGND sg13g2_fill_2
XFILLER_15_787 VPWR VGND sg13g2_decap_8
XFILLER_30_724 VPWR VGND sg13g2_decap_8
Xu_ppwm_u_ex__0760_ u_ppwm_u_ex__0760_/A u_ppwm_u_ex__0759_/A u_ppwm_u_ex__0760_/Y
+ VPWR VGND sg13g2_nor2b_1
Xu_ppwm_u_mem__0972_ VGND VPWR u_ppwm_u_mem__0646_/Y net398 u_ppwm_u_mem__1156_/D
+ u_ppwm_u_mem__0971_/Y sg13g2_a21oi_1
XFILLER_7_953 VPWR VGND sg13g2_decap_8
Xu_ppwm_u_pwm__214_ u_ppwm_u_pwm__214_/A u_ppwm_u_pwm__214_/B u_ppwm_u_pwm__214_/C
+ u_ppwm_u_pwm__214_/D u_ppwm_u_pwm__214_/X VPWR VGND sg13g2_or4_1
Xu_ppwm_u_pwm__145_ hold236/A net476 hold245/A u_ppwm_u_pwm__146_/D VPWR VGND sg13g2_nand3_1
XFILLER_6_463 VPWR VGND sg13g2_decap_8
XFILLER_10_481 VPWR VGND sg13g2_decap_8
Xu_ppwm_u_ex__0691_ u_ppwm_u_ex__0691_/Y u_ppwm_u_ex__0688_/Y u_ppwm_u_ex__0690_/Y
+ u_ppwm_u_ex__0925_/A net432 VPWR VGND sg13g2_a22oi_1
Xu_ppwm_u_mem__1120__111 VPWR VGND net111 sg13g2_tiehi
XFILLER_49_172 VPWR VGND sg13g2_decap_4
Xu_ppwm_u_global_counter__163_ net60 VGND VPWR net673 hold288/A clknet_5_20__leaf_clk
+ sg13g2_dfrbpq_2
Xu_ppwm_u_global_counter__094_ VPWR u_ppwm_u_global_counter__141_/B net629 VGND sg13g2_inv_1
XFILLER_38_868 VPWR VGND sg13g2_decap_8
XFILLER_25_529 VPWR VGND sg13g2_decap_8
XFILLER_37_389 VPWR VGND sg13g2_fill_1
XFILLER_18_592 VPWR VGND sg13g2_decap_8
XFILLER_20_223 VPWR VGND sg13g2_fill_2
Xu_ppwm_u_mem__1088__194 VPWR VGND net194 sg13g2_tiehi
Xu_ppwm_u_ex__0958_ u_ppwm_u_ex__0958_/A u_ppwm_u_ex__0958_/B u_ppwm_u_ex__0958_/C
+ u_ppwm_u_ex__0958_/Y VPWR VGND sg13g2_nor3_1
XFILLER_21_757 VPWR VGND sg13g2_decap_8
Xu_ppwm_u_ex__0889_ VGND VPWR u_ppwm_u_ex__0887_/Y u_ppwm_u_ex__0889_/Y u_ppwm_u_ex__0888_/X
+ u_ppwm_u_ex__0854_/Y sg13g2_a21oi_2
Xu_ppwm_u_mem__1128__95 VPWR VGND net95 sg13g2_tiehi
XFILLER_18_45 VPWR VGND sg13g2_fill_1
XFILLER_29_857 VPWR VGND sg13g2_decap_8
XFILLER_44_838 VPWR VGND sg13g2_decap_8
XFILLER_28_378 VPWR VGND sg13g2_decap_4
XFILLER_43_337 VPWR VGND sg13g2_fill_1
XFILLER_12_702 VPWR VGND sg13g2_decap_8
XFILLER_24_551 VPWR VGND sg13g2_decap_8
XFILLER_11_212 VPWR VGND sg13g2_fill_2
XFILLER_8_717 VPWR VGND sg13g2_decap_8
XFILLER_12_779 VPWR VGND sg13g2_decap_8
XFILLER_20_790 VPWR VGND sg13g2_decap_8
XFILLER_4_956 VPWR VGND sg13g2_decap_8
XFILLER_3_455 VPWR VGND sg13g2_decap_8
XFILLER_47_632 VPWR VGND sg13g2_decap_8
Xu_ppwm_u_mem__1171_ net84 VGND VPWR net511 hold127/A clknet_5_24__leaf_clk sg13g2_dfrbpq_1
XFILLER_46_153 VPWR VGND sg13g2_decap_4
XFILLER_19_389 VPWR VGND sg13g2_fill_2
XFILLER_35_849 VPWR VGND sg13g2_decap_8
XFILLER_15_584 VPWR VGND sg13g2_decap_8
XFILLER_30_521 VPWR VGND sg13g2_decap_8
Xu_ppwm_u_ex__0812_ u_ppwm/instr\[2\] u_ppwm_u_ex__0812_/B u_ppwm_u_ex__0813_/A VPWR
+ VGND sg13g2_nor2_1
XFILLER_30_598 VPWR VGND sg13g2_decap_8
Xu_ppwm_u_ex__0743_ VGND VPWR u_ppwm_u_ex__0737_/Y u_ppwm_u_ex__0738_/Y u_ppwm_u_ex__0743_/Y
+ u_ppwm_u_ex__0742_/Y sg13g2_a21oi_1
XFILLER_7_750 VPWR VGND sg13g2_decap_8
Xu_ppwm_u_mem__0955_ net484 VPWR u_ppwm_u_mem__0955_/Y VGND hold183/A net383 sg13g2_o21ai_1
Xu_ppwm_u_mem__0886_ VGND VPWR u_ppwm_u_mem__0689_/Y net399 hold75/A u_ppwm_u_mem__0885_/Y
+ sg13g2_a21oi_1
XFILLER_6_260 VPWR VGND sg13g2_fill_2
Xu_ppwm_u_ex__0674_ net377 net374 u_ppwm_u_ex__0993_/B VPWR VGND sg13g2_nor2_1
Xu_ppwm_u_pwm__128_ VPWR u_ppwm_u_pwm__128_/Y net575 VGND sg13g2_inv_1
XFILLER_27_0 VPWR VGND sg13g2_decap_8
Xu_ppwm_u_global_counter__146_ net423 u_ppwm_u_global_counter__156_/C net422 u_ppwm_u_global_counter__147_/B
+ VPWR VGND sg13g2_nand3_1
XFILLER_38_665 VPWR VGND sg13g2_decap_8
XFILLER_26_816 VPWR VGND sg13g2_decap_8
Xu_ppwm_u_ex__1088_ VGND VPWR u_ppwm_u_ex__1088_/X u_ppwm_u_ex__1088_/B u_ppwm_u_ex__1088_/A
+ sg13g2_or2_1
XFILLER_25_348 VPWR VGND sg13g2_fill_2
XFILLER_34_871 VPWR VGND sg13g2_decap_8
XFILLER_21_554 VPWR VGND sg13g2_decap_8
XFILLER_14_1010 VPWR VGND sg13g2_decap_8
XFILLER_49_908 VPWR VGND sg13g2_decap_8
XFILLER_1_937 VPWR VGND sg13g2_decap_8
Xhold22 hold22/A VPWR VGND net239 sg13g2_dlygate4sd3_1
Xhold11 hold11/A VPWR VGND net228 sg13g2_dlygate4sd3_1
XFILLER_0_469 VPWR VGND sg13g2_decap_8
XFILLER_29_33 VPWR VGND sg13g2_fill_2
XFILLER_48_429 VPWR VGND sg13g2_decap_8
XFILLER_29_66 VPWR VGND sg13g2_decap_8
XFILLER_29_77 VPWR VGND sg13g2_fill_1
Xhold33 hold33/A VPWR VGND net250 sg13g2_dlygate4sd3_1
Xhold44 hold44/A VPWR VGND net261 sg13g2_dlygate4sd3_1
Xhold55 hold55/A VPWR VGND net272 sg13g2_dlygate4sd3_1
Xhold66 hold66/A VPWR VGND net283 sg13g2_dlygate4sd3_1
Xhold77 hold77/A VPWR VGND net294 sg13g2_dlygate4sd3_1
XFILLER_29_654 VPWR VGND sg13g2_decap_8
Xhold99 hold99/A VPWR VGND net316 sg13g2_dlygate4sd3_1
Xhold88 hold88/A VPWR VGND net305 sg13g2_dlygate4sd3_1
XFILLER_16_304 VPWR VGND sg13g2_fill_2
XFILLER_44_635 VPWR VGND sg13g2_decap_8
XFILLER_16_348 VPWR VGND sg13g2_fill_2
XFILLER_45_98 VPWR VGND sg13g2_decap_8
XFILLER_43_178 VPWR VGND sg13g2_fill_1
XFILLER_25_893 VPWR VGND sg13g2_decap_8
XFILLER_40_863 VPWR VGND sg13g2_decap_8
XFILLER_8_514 VPWR VGND sg13g2_decap_8
XFILLER_12_576 VPWR VGND sg13g2_decap_8
Xu_ppwm_u_mem__0740_ u_ppwm_u_mem__0740_/Y hold122/A net468 VPWR VGND sg13g2_nand2b_1
Xu_ppwm_u_mem__0671_ VPWR u_ppwm_u_mem__0671_/Y net314 VGND sg13g2_inv_1
XFILLER_4_753 VPWR VGND sg13g2_decap_8
Xu_ppwm_u_ex__1011_ net496 VPWR u_ppwm_u_ex__1012_/B VGND net440 net343 sg13g2_o21ai_1
XFILLER_48_996 VPWR VGND sg13g2_decap_8
Xu_ppwm_u_mem__1154_ net151 VGND VPWR u_ppwm_u_mem__1154_/D hold184/A clknet_5_8__leaf_clk
+ sg13g2_dfrbpq_1
XFILLER_35_646 VPWR VGND sg13g2_decap_8
Xu_ppwm_u_mem__1085_ u_ppwm_u_mem__1086_/B hold239/A net518 VPWR VGND sg13g2_nand2_1
XFILLER_23_819 VPWR VGND sg13g2_decap_8
XFILLER_31_852 VPWR VGND sg13g2_decap_8
Xu_ppwm_u_mem__0938_ VGND VPWR u_ppwm_u_mem__0663_/Y net418 u_ppwm_u_mem__1139_/D
+ u_ppwm_u_mem__0937_/Y sg13g2_a21oi_1
Xu_ppwm_u_ex__0726_ net368 u_ppwm_u_ex__0993_/B fanout358/A VPWR VGND sg13g2_and2_1
Xu_ppwm_u_mem__0869_ net489 VPWR u_ppwm_u_mem__0869_/Y VGND net303 net399 sg13g2_o21ai_1
Xu_ppwm_u_ex__0657_ u_ppwm_u_ex__0657_/Y u_ppwm_u_ex__0689_/B net427 VPWR VGND sg13g2_nand2_1
Xu_ppwm_u_ex__0588_ net494 u_ppwm_u_ex__0782_/A VPWR VGND sg13g2_inv_4
XFILLER_39_941 VPWR VGND sg13g2_decap_8
XFILLER_26_613 VPWR VGND sg13g2_decap_8
Xu_ppwm_u_global_counter__129_ u_ppwm_u_global_counter__130_/B u_ppwm_u_global_counter__129_/A
+ u_ppwm_u_global_counter__132_/D VPWR VGND sg13g2_nand2_1
XFILLER_25_123 VPWR VGND sg13g2_decap_4
XFILLER_25_178 VPWR VGND sg13g2_fill_2
XFILLER_22_896 VPWR VGND sg13g2_decap_8
XFILLER_5_517 VPWR VGND sg13g2_decap_8
XFILLER_1_734 VPWR VGND sg13g2_decap_8
XFILLER_49_705 VPWR VGND sg13g2_decap_8
XFILLER_45_900 VPWR VGND sg13g2_decap_8
XFILLER_45_977 VPWR VGND sg13g2_decap_8
XFILLER_17_657 VPWR VGND sg13g2_decap_8
Xu_ppwm_u_pwm__255__210 VPWR VGND net210 sg13g2_tiehi
XFILLER_32_627 VPWR VGND sg13g2_decap_8
XFILLER_9_801 VPWR VGND sg13g2_decap_8
XFILLER_25_690 VPWR VGND sg13g2_decap_8
XFILLER_40_660 VPWR VGND sg13g2_decap_8
XFILLER_13_896 VPWR VGND sg13g2_decap_8
XFILLER_9_878 VPWR VGND sg13g2_decap_8
Xu_ppwm_u_mem__0723_ u_ppwm_u_mem__0723_/Y hold92/A net468 VPWR VGND sg13g2_nand2_1
XFILLER_4_550 VPWR VGND sg13g2_decap_8
Xu_ppwm_u_mem__0654_ VPWR u_ppwm_u_mem__0654_/Y net521 VGND sg13g2_inv_1
Xu_ppwm_u_mem__1156__143 VPWR VGND net143 sg13g2_tiehi
XFILLER_36_900 VPWR VGND sg13g2_decap_8
XFILLER_48_793 VPWR VGND sg13g2_decap_8
XFILLER_47_292 VPWR VGND sg13g2_fill_2
Xu_ppwm_u_mem__1206_ net94 VGND VPWR net623 hold239/A clknet_5_2__leaf_clk sg13g2_dfrbpq_2
Xu_ppwm_u_mem__1137_ net77 VGND VPWR u_ppwm_u_mem__1137_/D hold83/A clknet_5_28__leaf_clk
+ sg13g2_dfrbpq_1
Xheichips25_ppwm_5 VPWR VGND uio_oe[1] sg13g2_tielo
XFILLER_35_443 VPWR VGND sg13g2_fill_2
XFILLER_36_977 VPWR VGND sg13g2_decap_8
XFILLER_22_115 VPWR VGND sg13g2_decap_8
XFILLER_23_616 VPWR VGND sg13g2_decap_8
Xu_ppwm_u_mem__1068_ VGND VPWR hold252/A hold243/A hold95/A net311 sg13g2_a21oi_1
Xhold300 hold300/A VPWR VGND net683 sg13g2_dlygate4sd3_1
Xu_ppwm_u_ex__0709_ hold225/A hold277/A u_ppwm_u_ex__0709_/Y VPWR VGND sg13g2_nor2b_1
XFILLER_27_911 VPWR VGND sg13g2_decap_8
XFILLER_26_45 VPWR VGND sg13g2_decap_8
XFILLER_27_988 VPWR VGND sg13g2_decap_8
XFILLER_26_487 VPWR VGND sg13g2_decap_8
XFILLER_42_958 VPWR VGND sg13g2_decap_8
XFILLER_41_468 VPWR VGND sg13g2_decap_8
XFILLER_22_693 VPWR VGND sg13g2_decap_8
XFILLER_10_866 VPWR VGND sg13g2_decap_8
XFILLER_6_848 VPWR VGND sg13g2_decap_8
XFILLER_1_531 VPWR VGND sg13g2_decap_8
XFILLER_49_502 VPWR VGND sg13g2_decap_8
XFILLER_49_579 VPWR VGND sg13g2_decap_8
XFILLER_18_900 VPWR VGND sg13g2_decap_8
XFILLER_18_977 VPWR VGND sg13g2_decap_8
XFILLER_29_292 VPWR VGND sg13g2_fill_2
XFILLER_33_914 VPWR VGND sg13g2_decap_8
XFILLER_45_774 VPWR VGND sg13g2_decap_8
Xu_ppwm_u_ex__0991_ u_ppwm_u_ex__0991_/Y fanout348/A fanout428/A net359 net450 VPWR
+ VGND sg13g2_a22oi_1
Xu_ppwm_u_mem__1186__114 VPWR VGND net114 sg13g2_tiehi
XFILLER_20_608 VPWR VGND sg13g2_decap_8
XFILLER_13_693 VPWR VGND sg13g2_decap_8
XFILLER_8_152 VPWR VGND sg13g2_fill_2
XFILLER_9_675 VPWR VGND sg13g2_decap_8
Xu_ppwm_u_mem__0706_ VPWR u_ppwm_u_mem__0706_/Y net239 VGND sg13g2_inv_1
XFILLER_5_881 VPWR VGND sg13g2_decap_8
Xu_ppwm_u_mem__0637_ VPWR u_ppwm_u_mem__0637_/Y net337 VGND sg13g2_inv_1
XFILLER_41_1028 VPWR VGND sg13g2_fill_1
XFILLER_48_590 VPWR VGND sg13g2_decap_8
XFILLER_23_402 VPWR VGND sg13g2_decap_8
XFILLER_24_936 VPWR VGND sg13g2_decap_8
XFILLER_36_774 VPWR VGND sg13g2_decap_8
XFILLER_35_284 VPWR VGND sg13g2_fill_1
XFILLER_11_619 VPWR VGND sg13g2_decap_8
XFILLER_10_118 VPWR VGND sg13g2_fill_2
XFILLER_32_991 VPWR VGND sg13g2_decap_8
Xhold152 hold152/A VPWR VGND net535 sg13g2_dlygate4sd3_1
Xhold130 hold130/A VPWR VGND net513 sg13g2_dlygate4sd3_1
Xhold141 hold141/A VPWR VGND net524 sg13g2_dlygate4sd3_1
XFILLER_5_8 VPWR VGND sg13g2_decap_8
Xhold174 hold174/A VPWR VGND net557 sg13g2_dlygate4sd3_1
Xhold185 hold185/A VPWR VGND net568 sg13g2_dlygate4sd3_1
Xhold163 hold163/A VPWR VGND net546 sg13g2_dlygate4sd3_1
Xhold196 hold196/A VPWR VGND net579 sg13g2_dlygate4sd3_1
XFILLER_46_538 VPWR VGND sg13g2_decap_8
XFILLER_26_240 VPWR VGND sg13g2_fill_1
XFILLER_27_785 VPWR VGND sg13g2_decap_8
XFILLER_42_755 VPWR VGND sg13g2_decap_8
XFILLER_14_424 VPWR VGND sg13g2_fill_1
XFILLER_15_969 VPWR VGND sg13g2_decap_8
XFILLER_18_1019 VPWR VGND sg13g2_decap_8
XFILLER_30_906 VPWR VGND sg13g2_decap_8
XFILLER_14_457 VPWR VGND sg13g2_fill_1
Xu_ppwm_u_pwm__230_ VGND VPWR u_ppwm_u_pwm__230_/X u_ppwm_u_pwm__230_/B u_ppwm_u_pwm__230_/A
+ sg13g2_or2_1
XFILLER_23_980 VPWR VGND sg13g2_decap_8
Xu_ppwm_u_pwm__161_ u_ppwm_u_pwm__175_/A net584 u_ppwm_u_pwm__163_/B hold202/A VPWR
+ VGND sg13g2_nor3_1
XFILLER_10_663 VPWR VGND sg13g2_decap_8
XFILLER_22_490 VPWR VGND sg13g2_decap_8
XFILLER_6_645 VPWR VGND sg13g2_decap_8
XFILLER_5_177 VPWR VGND sg13g2_fill_2
XFILLER_2_851 VPWR VGND sg13g2_decap_8
XFILLER_49_376 VPWR VGND sg13g2_decap_8
Xu_ppwm_u_mem__1192__184 VPWR VGND net184 sg13g2_tiehi
XFILLER_45_571 VPWR VGND sg13g2_decap_8
XFILLER_18_774 VPWR VGND sg13g2_decap_8
XFILLER_33_711 VPWR VGND sg13g2_decap_8
XFILLER_21_939 VPWR VGND sg13g2_decap_8
XFILLER_33_788 VPWR VGND sg13g2_decap_8
Xu_ppwm_u_ex__0974_ VGND VPWR net350 u_ppwm_u_ex__0965_/Y u_ppwm_u_ex__0976_/A u_ppwm_u_ex__0973_/Y
+ sg13g2_a21oi_1
XFILLER_13_490 VPWR VGND sg13g2_decap_8
Xheichips25_ppwm_26 VPWR VGND uo_out[7] sg13g2_tielo
Xheichips25_ppwm_15 VPWR VGND uio_out[3] sg13g2_tielo
XFILLER_43_519 VPWR VGND sg13g2_decap_8
XFILLER_36_571 VPWR VGND sg13g2_decap_8
XFILLER_24_733 VPWR VGND sg13g2_decap_8
Xu_ppwm_u_mem__1170__88 VPWR VGND net88 sg13g2_tiehi
XFILLER_23_79 VPWR VGND sg13g2_fill_1
XFILLER_20_972 VPWR VGND sg13g2_decap_8
XFILLER_3_637 VPWR VGND sg13g2_decap_8
XFILLER_2_125 VPWR VGND sg13g2_decap_8
XFILLER_2_136 VPWR VGND sg13g2_decap_4
XFILLER_48_21 VPWR VGND sg13g2_decap_8
Xfanout440 net682 net440 VPWR VGND sg13g2_buf_8
XFILLER_47_814 VPWR VGND sg13g2_decap_8
Xfanout484 net492 net484 VPWR VGND sg13g2_buf_8
Xfanout462 fanout462/A net462 VPWR VGND sg13g2_buf_8
Xfanout451 net641 net451 VPWR VGND sg13g2_buf_8
Xfanout473 net474 net473 VPWR VGND sg13g2_buf_8
Xfanout495 net497 net495 VPWR VGND sg13g2_buf_8
XFILLER_0_28 VPWR VGND sg13g2_decap_8
XFILLER_27_582 VPWR VGND sg13g2_decap_8
XFILLER_42_552 VPWR VGND sg13g2_decap_8
XFILLER_9_26 VPWR VGND sg13g2_fill_2
XFILLER_15_766 VPWR VGND sg13g2_decap_8
XFILLER_30_703 VPWR VGND sg13g2_decap_8
Xu_ppwm_u_mem__0971_ net487 VPWR u_ppwm_u_mem__0971_/Y VGND net319 net389 sg13g2_o21ai_1
Xu_ppwm_u_ex__0690_ VGND VPWR u_ppwm_u_ex__0573_/Y net443 u_ppwm_u_ex__0690_/Y u_ppwm_u_ex__0689_/Y
+ sg13g2_a21oi_1
XFILLER_7_932 VPWR VGND sg13g2_decap_8
Xu_ppwm_u_pwm__213_ hold229/A hold197/A u_ppwm_u_pwm__214_/D VPWR VGND sg13g2_nor2b_1
XFILLER_11_983 VPWR VGND sg13g2_decap_8
XFILLER_31_1027 VPWR VGND sg13g2_fill_2
Xu_ppwm_u_pwm__144_ hold189/A net571 hold210/A VPWR VGND sg13g2_nand2_1
XFILLER_6_442 VPWR VGND sg13g2_decap_8
XFILLER_29_4 VPWR VGND sg13g2_fill_2
Xu_ppwm_u_global_counter__162_ net62 VGND VPWR net657 hold272/A clknet_5_21__leaf_clk
+ sg13g2_dfrbpq_2
XFILLER_38_847 VPWR VGND sg13g2_decap_8
Xu_ppwm_u_global_counter__093_ VPWR u_ppwm_u_global_counter__141_/A net605 VGND sg13g2_inv_1
XFILLER_18_571 VPWR VGND sg13g2_decap_8
XFILLER_25_508 VPWR VGND sg13g2_decap_8
XFILLER_21_736 VPWR VGND sg13g2_decap_8
XFILLER_33_585 VPWR VGND sg13g2_decap_8
Xu_ppwm_u_ex__0957_ u_ppwm_u_ex__0957_/A u_ppwm_u_ex__0957_/B u_ppwm_u_ex__1129_/D
+ VPWR VGND sg13g2_nor2_1
XFILLER_20_235 VPWR VGND sg13g2_fill_2
Xu_ppwm_u_ex__0888_ u_ppwm_u_ex__0888_/X u_ppwm_u_ex__0888_/A u_ppwm_u_ex__0888_/B
+ u_ppwm_u_ex__0888_/C VPWR VGND sg13g2_and3_1
XFILLER_18_35 VPWR VGND sg13g2_fill_1
XFILLER_28_313 VPWR VGND sg13g2_fill_2
XFILLER_29_836 VPWR VGND sg13g2_decap_8
XFILLER_44_817 VPWR VGND sg13g2_decap_8
XFILLER_24_530 VPWR VGND sg13g2_decap_8
XFILLER_12_758 VPWR VGND sg13g2_decap_8
Xclkload0 VPWR clkload0/Y clknet_5_1__leaf_clk VGND sg13g2_inv_1
XFILLER_4_935 VPWR VGND sg13g2_decap_8
XFILLER_3_434 VPWR VGND sg13g2_decap_8
Xclkbuf_5_29__f_clk clknet_4_14_0_clk clknet_5_29__leaf_clk VPWR VGND sg13g2_buf_8
XFILLER_47_611 VPWR VGND sg13g2_decap_8
Xu_ppwm_u_mem__1170_ net88 VGND VPWR net269 hold51/A clknet_5_12__leaf_clk sg13g2_dfrbpq_1
XFILLER_47_688 VPWR VGND sg13g2_decap_8
XFILLER_35_828 VPWR VGND sg13g2_decap_8
XFILLER_15_563 VPWR VGND sg13g2_decap_8
XFILLER_43_883 VPWR VGND sg13g2_decap_8
XFILLER_42_382 VPWR VGND sg13g2_decap_4
XFILLER_30_500 VPWR VGND sg13g2_decap_8
Xu_ppwm_u_ex__0811_ u_ppwm_u_ex__0993_/B net356 net353 u_ppwm_u_ex__0815_/B VPWR VGND
+ sg13g2_or3_1
XFILLER_30_577 VPWR VGND sg13g2_decap_8
Xu_ppwm_u_mem__0954_ VGND VPWR u_ppwm_u_mem__0655_/Y net383 u_ppwm_u_mem__1147_/D
+ u_ppwm_u_mem__0953_/Y sg13g2_a21oi_1
Xu_ppwm_u_ex__0742_ u_ppwm_u_ex__0742_/B u_ppwm_u_ex__0744_/C u_ppwm_u_ex__0742_/A
+ u_ppwm_u_ex__0742_/Y VPWR VGND sg13g2_nand3_1
XFILLER_11_780 VPWR VGND sg13g2_decap_8
Xu_ppwm_u_mem__0885_ net489 VPWR u_ppwm_u_mem__0885_/Y VGND hold173/A net399 sg13g2_o21ai_1
XFILLER_10_290 VPWR VGND sg13g2_decap_8
Xu_ppwm_u_ex__0673_ u_ppwm_u_ex__0673_/Y u_ppwm_u_ex__0601_/Y net441 u_ppwm_u_ex__0600_/Y
+ hold271/A VPWR VGND sg13g2_a22oi_1
Xu_ppwm_u_global_counter__145_ VGND VPWR net423 u_ppwm_u_global_counter__156_/C hold267/A
+ net422 sg13g2_a21oi_1
XFILLER_37_110 VPWR VGND sg13g2_decap_4
XFILLER_38_644 VPWR VGND sg13g2_decap_8
Xu_ppwm_u_ex__1087_ u_ppwm_u_ex__1088_/B u_ppwm_u_ex__1087_/A u_ppwm_u_ex__1087_/B
+ VPWR VGND sg13g2_nand2_1
XFILLER_34_850 VPWR VGND sg13g2_decap_8
XFILLER_21_533 VPWR VGND sg13g2_decap_8
XFILLER_1_916 VPWR VGND sg13g2_decap_8
XFILLER_48_408 VPWR VGND sg13g2_decap_8
Xhold23 hold23/A VPWR VGND net240 sg13g2_dlygate4sd3_1
Xhold12 hold12/A VPWR VGND net229 sg13g2_dlygate4sd3_1
XFILLER_0_448 VPWR VGND sg13g2_decap_8
Xhold34 hold34/A VPWR VGND net251 sg13g2_dlygate4sd3_1
Xhold56 hold56/A VPWR VGND net273 sg13g2_dlygate4sd3_1
XFILLER_29_45 VPWR VGND sg13g2_fill_2
Xhold45 hold45/A VPWR VGND net262 sg13g2_dlygate4sd3_1
Xhold78 hold78/A VPWR VGND net295 sg13g2_dlygate4sd3_1
XFILLER_29_633 VPWR VGND sg13g2_decap_8
Xhold67 hold67/A VPWR VGND net284 sg13g2_dlygate4sd3_1
Xhold89 hold89/A VPWR VGND net306 sg13g2_dlygate4sd3_1
XFILLER_44_614 VPWR VGND sg13g2_decap_8
XFILLER_17_839 VPWR VGND sg13g2_decap_8
XFILLER_32_809 VPWR VGND sg13g2_decap_8
XFILLER_25_872 VPWR VGND sg13g2_decap_8
XFILLER_40_842 VPWR VGND sg13g2_decap_8
XFILLER_12_555 VPWR VGND sg13g2_decap_8
Xu_ppwm_u_mem__0670_ VPWR u_ppwm_u_mem__0670_/Y net295 VGND sg13g2_inv_1
XFILLER_4_732 VPWR VGND sg13g2_decap_8
XFILLER_6_1009 VPWR VGND sg13g2_decap_8
Xu_ppwm_u_ex__1010_ u_ppwm_u_ex__1010_/A u_ppwm_u_ex__1010_/B u_ppwm_u_ex__1010_/C
+ u_ppwm_u_ex__1010_/D u_ppwm_u_ex__1012_/A VPWR VGND sg13g2_nor4_1
XFILLER_48_975 VPWR VGND sg13g2_decap_8
XFILLER_19_154 VPWR VGND sg13g2_fill_1
Xu_ppwm_u_mem__1153_ net155 VGND VPWR net232 hold14/A clknet_5_9__leaf_clk sg13g2_dfrbpq_1
XFILLER_47_485 VPWR VGND sg13g2_decap_8
XFILLER_35_625 VPWR VGND sg13g2_decap_8
Xu_ppwm_u_mem__1084_ u_ppwm_u_mem__1084_/A u_ppwm_u_mem__1082_/Y hold240/A VPWR VGND
+ sg13g2_nor2b_1
XFILLER_43_680 VPWR VGND sg13g2_decap_8
XFILLER_37_1022 VPWR VGND sg13g2_decap_8
XFILLER_15_382 VPWR VGND sg13g2_fill_1
XFILLER_31_831 VPWR VGND sg13g2_decap_8
Xu_ppwm_u_mem__1130__91 VPWR VGND net91 sg13g2_tiehi
Xu_ppwm_u_mem__0937_ net501 VPWR u_ppwm_u_mem__0937_/Y VGND net251 net418 sg13g2_o21ai_1
Xu_ppwm_u_ex__0725_ u_ppwm_u_ex__0724_/Y VPWR u_ppwm_u_ex__0728_/A VGND u_ppwm_u_ex__0716_/Y
+ u_ppwm_u_ex__0718_/Y sg13g2_o21ai_1
Xu_ppwm_u_mem__0868_ VGND VPWR u_ppwm_u_mem__0698_/Y net400 hold167/A u_ppwm_u_mem__0867_/Y
+ sg13g2_a21oi_1
Xu_ppwm_u_ex__0656_ u_ppwm_u_ex__0656_/Y u_ppwm_u_ex__0603_/Y net444 u_ppwm_u_ex__0602_/Y
+ hold294/A VPWR VGND sg13g2_a22oi_1
Xu_ppwm_u_ex__0587_ VPWR u_ppwm_u_ex__0637_/A net467 VGND sg13g2_inv_1
Xu_ppwm_u_mem__0799_ u_ppwm_u_mem__0799_/Y u_ppwm_u_mem__0831_/A u_ppwm_u_mem__0799_/B
+ VPWR VGND sg13g2_nand2_1
Xclkbuf_5_12__f_clk clknet_4_6_0_clk clknet_5_12__leaf_clk VPWR VGND sg13g2_buf_8
XFILLER_39_920 VPWR VGND sg13g2_decap_8
XFILLER_39_997 VPWR VGND sg13g2_decap_8
XFILLER_38_452 VPWR VGND sg13g2_fill_2
Xu_ppwm_u_global_counter__128_ net617 net424 u_ppwm_u_global_counter__132_/D VPWR
+ VGND sg13g2_and2_1
Xu_ppwm_u_ex__1139_ net45 VGND VPWR u_ppwm_u_ex__1139_/D hold275/A clknet_5_18__leaf_clk
+ sg13g2_dfrbpq_2
XFILLER_26_669 VPWR VGND sg13g2_decap_8
XFILLER_15_25 VPWR VGND sg13g2_decap_8
XFILLER_21_330 VPWR VGND sg13g2_decap_8
XFILLER_22_875 VPWR VGND sg13g2_decap_8
XFILLER_1_713 VPWR VGND sg13g2_decap_8
XFILLER_0_267 VPWR VGND sg13g2_decap_4
XFILLER_0_289 VPWR VGND sg13g2_decap_4
XFILLER_45_956 VPWR VGND sg13g2_decap_8
XFILLER_17_636 VPWR VGND sg13g2_decap_8
XFILLER_32_606 VPWR VGND sg13g2_decap_8
XFILLER_44_488 VPWR VGND sg13g2_decap_8
XFILLER_24_190 VPWR VGND sg13g2_fill_2
XFILLER_13_875 VPWR VGND sg13g2_decap_8
XFILLER_9_857 VPWR VGND sg13g2_decap_8
Xu_ppwm_u_mem__0722_ net453 u_ppwm_u_mem__0722_/B u_ppwm_u_mem__0722_/Y VPWR VGND
+ sg13g2_nor2_1
Xu_ppwm_u_mem__0653_ VPWR u_ppwm_u_mem__0653_/Y net566 VGND sg13g2_inv_1
XFILLER_39_216 VPWR VGND sg13g2_fill_2
Xu_ppwm_u_mem__1117__117 VPWR VGND net117 sg13g2_tiehi
XFILLER_39_238 VPWR VGND sg13g2_fill_1
XFILLER_48_772 VPWR VGND sg13g2_decap_8
XFILLER_11_4 VPWR VGND sg13g2_decap_4
Xu_ppwm_u_mem__1205_ net157 VGND VPWR net520 hold135/A clknet_5_2__leaf_clk sg13g2_dfrbpq_1
XFILLER_35_422 VPWR VGND sg13g2_fill_1
XFILLER_36_956 VPWR VGND sg13g2_decap_8
Xu_ppwm_u_mem__1136_ net79 VGND VPWR u_ppwm_u_mem__1136_/D hold164/A clknet_5_28__leaf_clk
+ sg13g2_dfrbpq_1
Xheichips25_ppwm_6 VPWR VGND uio_oe[2] sg13g2_tielo
Xu_ppwm_u_mem__1067_ u_ppwm_u_mem__1069_/B u_ppwm_u_mem__1066_/Y u_ppwm_u_mem__0833_/Y
+ u_ppwm_u_mem__1060_/X net311 VPWR VGND sg13g2_a22oi_1
XFILLER_35_499 VPWR VGND sg13g2_decap_8
XFILLER_22_149 VPWR VGND sg13g2_decap_4
XFILLER_7_81 VPWR VGND sg13g2_decap_4
XFILLER_11_1025 VPWR VGND sg13g2_decap_4
Xhold301 hold301/A VPWR VGND net684 sg13g2_dlygate4sd3_1
Xu_ppwm_u_ex__0708_ u_ppwm_u_ex__0708_/Y hold296/A net448 VPWR VGND sg13g2_nand2b_1
Xu_ppwm_u_ex__0639_ u_ppwm_u_ex__0782_/A u_ppwm_u_ex__0639_/B u_ppwm_u_ex__0639_/C
+ u_ppwm_u_ex__1117_/D VPWR VGND sg13g2_nor3_1
XFILLER_45_208 VPWR VGND sg13g2_fill_2
XFILLER_39_794 VPWR VGND sg13g2_decap_8
XFILLER_27_967 VPWR VGND sg13g2_decap_8
XFILLER_42_937 VPWR VGND sg13g2_decap_8
XFILLER_14_639 VPWR VGND sg13g2_decap_8
XFILLER_26_466 VPWR VGND sg13g2_decap_8
XFILLER_10_845 VPWR VGND sg13g2_decap_8
XFILLER_21_160 VPWR VGND sg13g2_decap_4
XFILLER_22_672 VPWR VGND sg13g2_decap_8
XFILLER_6_827 VPWR VGND sg13g2_decap_8
XFILLER_1_510 VPWR VGND sg13g2_decap_8
XFILLER_1_587 VPWR VGND sg13g2_decap_8
XFILLER_49_558 VPWR VGND sg13g2_decap_8
XFILLER_45_753 VPWR VGND sg13g2_decap_8
XFILLER_18_956 VPWR VGND sg13g2_decap_8
XFILLER_32_414 VPWR VGND sg13g2_decap_8
Xu_ppwm_u_ex__0990_ u_ppwm_u_ex__0990_/Y net608 net347 VPWR VGND sg13g2_nand2_1
XFILLER_32_425 VPWR VGND sg13g2_fill_2
XFILLER_13_672 VPWR VGND sg13g2_decap_8
XFILLER_34_1025 VPWR VGND sg13g2_decap_4
XFILLER_9_654 VPWR VGND sg13g2_decap_8
XFILLER_12_182 VPWR VGND sg13g2_fill_1
XFILLER_8_164 VPWR VGND sg13g2_fill_1
XFILLER_5_860 VPWR VGND sg13g2_decap_8
Xu_ppwm_u_mem__0705_ VPWR u_ppwm_u_mem__0705_/Y net538 VGND sg13g2_inv_1
Xu_ppwm_u_mem__0636_ VPWR u_ppwm_u_mem__0636_/Y net256 VGND sg13g2_inv_1
XFILLER_41_1007 VPWR VGND sg13g2_decap_8
XFILLER_27_219 VPWR VGND sg13g2_fill_2
XFILLER_36_753 VPWR VGND sg13g2_decap_8
Xu_ppwm_u_mem__1119_ net113 VGND VPWR u_ppwm_u_mem__1119_/D hold181/A clknet_5_27__leaf_clk
+ sg13g2_dfrbpq_1
XFILLER_23_414 VPWR VGND sg13g2_fill_2
XFILLER_24_915 VPWR VGND sg13g2_decap_8
XFILLER_35_296 VPWR VGND sg13g2_fill_1
XFILLER_23_469 VPWR VGND sg13g2_decap_8
XFILLER_32_970 VPWR VGND sg13g2_decap_8
XFILLER_3_819 VPWR VGND sg13g2_decap_8
Xhold142 hold142/A VPWR VGND net525 sg13g2_dlygate4sd3_1
Xhold153 hold153/A VPWR VGND net536 sg13g2_dlygate4sd3_1
Xhold120 hold120/A VPWR VGND net337 sg13g2_dlygate4sd3_1
Xhold131 hold131/A VPWR VGND net514 sg13g2_dlygate4sd3_1
Xhold186 hold186/A VPWR VGND net569 sg13g2_dlygate4sd3_1
Xhold164 hold164/A VPWR VGND net547 sg13g2_dlygate4sd3_1
Xhold175 hold175/A VPWR VGND net558 sg13g2_dlygate4sd3_1
Xhold197 hold197/A VPWR VGND net580 sg13g2_dlygate4sd3_1
XFILLER_46_517 VPWR VGND sg13g2_decap_8
XFILLER_2_1012 VPWR VGND sg13g2_decap_8
XFILLER_39_591 VPWR VGND sg13g2_decap_8
XFILLER_26_263 VPWR VGND sg13g2_fill_2
XFILLER_27_764 VPWR VGND sg13g2_decap_8
XFILLER_42_734 VPWR VGND sg13g2_decap_8
XFILLER_15_948 VPWR VGND sg13g2_decap_8
Xu_ppwm_u_ex__1138__53 VPWR VGND net53 sg13g2_tiehi
Xu_ppwm_u_pwm__160_ u_ppwm_u_pwm__160_/A u_ppwm_u_pwm__160_/B u_ppwm_u_pwm__160_/C
+ u_ppwm_u_pwm__163_/B VPWR VGND sg13g2_nor3_1
XFILLER_10_642 VPWR VGND sg13g2_decap_8
XFILLER_6_624 VPWR VGND sg13g2_decap_8
XFILLER_2_830 VPWR VGND sg13g2_decap_8
XFILLER_49_322 VPWR VGND sg13g2_fill_1
XFILLER_1_384 VPWR VGND sg13g2_decap_8
XFILLER_49_355 VPWR VGND sg13g2_decap_8
XFILLER_37_539 VPWR VGND sg13g2_decap_8
XFILLER_18_753 VPWR VGND sg13g2_decap_8
XFILLER_45_550 VPWR VGND sg13g2_decap_8
XFILLER_21_918 VPWR VGND sg13g2_decap_8
XFILLER_33_767 VPWR VGND sg13g2_decap_8
Xu_ppwm_u_ex__0973_ u_ppwm_u_ex__1099_/A u_ppwm_u_ex__0973_/C net346 u_ppwm_u_ex__0973_/Y
+ VPWR VGND sg13g2_nand3_1
Xu_ppwm_u_mem__0619_ VPWR u_ppwm_u_mem__0619_/Y net272 VGND sg13g2_inv_1
Xheichips25_ppwm_16 VPWR VGND uio_out[4] sg13g2_tielo
XFILLER_28_539 VPWR VGND sg13g2_decap_8
XFILLER_24_712 VPWR VGND sg13g2_decap_8
XFILLER_36_550 VPWR VGND sg13g2_decap_8
XFILLER_11_406 VPWR VGND sg13g2_fill_1
XFILLER_24_789 VPWR VGND sg13g2_decap_8
XFILLER_23_25 VPWR VGND sg13g2_decap_8
XFILLER_20_951 VPWR VGND sg13g2_decap_8
XFILLER_23_58 VPWR VGND sg13g2_fill_1
XFILLER_3_616 VPWR VGND sg13g2_decap_8
Xfanout441 net675 net441 VPWR VGND sg13g2_buf_8
Xfanout430 net676 net430 VPWR VGND sg13g2_buf_8
Xfanout463 net464 net463 VPWR VGND sg13g2_buf_8
XFILLER_24_1013 VPWR VGND sg13g2_decap_8
Xfanout474 fanout474/A net474 VPWR VGND sg13g2_buf_8
Xfanout452 hold258/A net452 VPWR VGND sg13g2_buf_1
XFILLER_48_88 VPWR VGND sg13g2_decap_8
Xfanout485 net486 net485 VPWR VGND sg13g2_buf_8
Xfanout496 net497 net496 VPWR VGND sg13g2_buf_2
XFILLER_27_561 VPWR VGND sg13g2_decap_8
XFILLER_42_531 VPWR VGND sg13g2_decap_8
XFILLER_15_745 VPWR VGND sg13g2_decap_8
Xu_ppwm_u_pwm__212_ VGND VPWR u_ppwm_u_pwm__210_/Y u_ppwm_u_pwm__211_/Y u_ppwm_u_pwm__212_/Y
+ u_ppwm_u_pwm__209_/Y sg13g2_a21oi_1
XFILLER_30_759 VPWR VGND sg13g2_decap_8
XFILLER_31_1006 VPWR VGND sg13g2_decap_8
Xu_ppwm_u_mem__0970_ VGND VPWR u_ppwm_u_mem__0647_/Y net392 u_ppwm_u_mem__1155_/D
+ u_ppwm_u_mem__0969_/Y sg13g2_a21oi_1
XFILLER_7_911 VPWR VGND sg13g2_decap_8
XFILLER_11_962 VPWR VGND sg13g2_decap_8
XFILLER_6_421 VPWR VGND sg13g2_decap_8
Xu_ppwm_u_pwm__143_ hold200/A hold250/A hold241/A u_ppwm_u_pwm__146_/B VPWR VGND sg13g2_nand3_1
XFILLER_7_988 VPWR VGND sg13g2_decap_8
XFILLER_6_498 VPWR VGND sg13g2_decap_8
XFILLER_9_1018 VPWR VGND sg13g2_decap_8
Xu_ppwm_u_global_counter__161_ net64 VGND VPWR net601 hold216/A clknet_5_21__leaf_clk
+ sg13g2_dfrbpq_2
XFILLER_49_163 VPWR VGND sg13g2_fill_1
XFILLER_38_826 VPWR VGND sg13g2_decap_8
Xu_ppwm_u_global_counter__092_ VPWR u_ppwm_u_global_counter__155_/C net639 VGND sg13g2_inv_1
XFILLER_18_550 VPWR VGND sg13g2_decap_8
XFILLER_46_881 VPWR VGND sg13g2_decap_8
XFILLER_45_391 VPWR VGND sg13g2_fill_2
XFILLER_33_564 VPWR VGND sg13g2_decap_8
XFILLER_21_715 VPWR VGND sg13g2_decap_8
Xu_ppwm_u_ex__0956_ net479 VPWR u_ppwm_u_ex__0957_/B VGND net659 net344 sg13g2_o21ai_1
XFILLER_20_258 VPWR VGND sg13g2_decap_4
XFILLER_9_292 VPWR VGND sg13g2_fill_2
Xu_ppwm_u_ex__0887_ VGND VPWR u_ppwm_u_ex__0658_/A u_ppwm_u_ex__0855_/A u_ppwm_u_ex__0887_/Y
+ u_ppwm_u_ex__0925_/B sg13g2_a21oi_1
XFILLER_47_1024 VPWR VGND sg13g2_decap_4
XFILLER_29_815 VPWR VGND sg13g2_decap_8
XFILLER_36_391 VPWR VGND sg13g2_fill_2
XFILLER_12_737 VPWR VGND sg13g2_decap_8
XFILLER_24_586 VPWR VGND sg13g2_decap_8
Xclkload1 clknet_5_3__leaf_clk clkload1/X VPWR VGND sg13g2_buf_1
XFILLER_4_914 VPWR VGND sg13g2_decap_8
XFILLER_3_413 VPWR VGND sg13g2_decap_8
XFILLER_47_667 VPWR VGND sg13g2_decap_8
XFILLER_19_358 VPWR VGND sg13g2_fill_2
XFILLER_35_807 VPWR VGND sg13g2_decap_8
XFILLER_46_188 VPWR VGND sg13g2_fill_2
XFILLER_43_862 VPWR VGND sg13g2_decap_8
XFILLER_15_542 VPWR VGND sg13g2_decap_8
Xu_ppwm_u_ex__0810_ u_ppwm_u_ex__0809_/Y u_ppwm_u_ex__0804_/Y u_ppwm_u_ex__0803_/X
+ u_ppwm_u_ex__0999_/A VPWR VGND sg13g2_a21o_1
XFILLER_30_556 VPWR VGND sg13g2_decap_8
Xu_ppwm_u_ex__0741_ u_ppwm_u_ex__0744_/C hold275/A hold254/A VPWR VGND sg13g2_nand2b_1
Xu_ppwm_u_mem__0953_ net484 VPWR u_ppwm_u_mem__0953_/Y VGND net521 net384 sg13g2_o21ai_1
Xu_ppwm_u_mem__0884_ VGND VPWR u_ppwm_u_mem__0690_/Y net400 u_ppwm_u_mem__1112_/D
+ u_ppwm_u_mem__0883_/Y sg13g2_a21oi_1
Xu_ppwm_u_ex__0672_ u_ppwm_u_ex__0671_/X VPWR u_ppwm_u_ex__0672_/Y VGND u_ppwm_u_ex__0665_/Y
+ u_ppwm_u_ex__0668_/Y sg13g2_o21ai_1
XFILLER_7_785 VPWR VGND sg13g2_decap_8
XFILLER_6_262 VPWR VGND sg13g2_fill_1
XFILLER_3_980 VPWR VGND sg13g2_decap_8
Xu_ppwm_u_mem__1159__131 VPWR VGND net131 sg13g2_tiehi
XFILLER_38_623 VPWR VGND sg13g2_decap_8
Xu_ppwm_u_global_counter__144_ VGND VPWR net423 u_ppwm_u_global_counter__156_/C hold263/A
+ u_ppwm_u_global_counter__143_/Y sg13g2_a21oi_1
Xu_ppwm_u_ex__1086_ VGND VPWR u_ppwm_u_ex__1079_/Y u_ppwm_u_ex__1084_/Y u_ppwm_u_ex__1139_/D
+ u_ppwm_u_ex__1085_/Y sg13g2_a21oi_1
XFILLER_21_512 VPWR VGND sg13g2_decap_8
XFILLER_21_589 VPWR VGND sg13g2_decap_8
Xu_ppwm_u_ex__0939_ VPWR VGND net432 u_ppwm_u_ex__0938_/X u_ppwm_u_ex__0970_/B hold291/A
+ u_ppwm_u_ex__0939_/Y net357 sg13g2_a221oi_1
XFILLER_0_427 VPWR VGND sg13g2_decap_8
Xhold13 hold13/A VPWR VGND net230 sg13g2_dlygate4sd3_1
XFILLER_29_35 VPWR VGND sg13g2_fill_1
Xhold46 hold46/A VPWR VGND net263 sg13g2_dlygate4sd3_1
XFILLER_29_612 VPWR VGND sg13g2_decap_8
Xhold24 hold24/A VPWR VGND net241 sg13g2_dlygate4sd3_1
Xhold35 hold35/A VPWR VGND net252 sg13g2_dlygate4sd3_1
Xhold57 hold57/A VPWR VGND net274 sg13g2_dlygate4sd3_1
XFILLER_21_1016 VPWR VGND sg13g2_decap_8
XFILLER_21_1027 VPWR VGND sg13g2_fill_2
Xhold79 hold79/A VPWR VGND net296 sg13g2_dlygate4sd3_1
Xhold68 hold68/A VPWR VGND net285 sg13g2_dlygate4sd3_1
XFILLER_17_818 VPWR VGND sg13g2_decap_8
XFILLER_29_689 VPWR VGND sg13g2_decap_8
XFILLER_45_56 VPWR VGND sg13g2_fill_2
XFILLER_16_328 VPWR VGND sg13g2_fill_2
XFILLER_25_851 VPWR VGND sg13g2_decap_8
XFILLER_40_821 VPWR VGND sg13g2_decap_8
XFILLER_24_372 VPWR VGND sg13g2_decap_4
XFILLER_12_534 VPWR VGND sg13g2_decap_8
XFILLER_40_898 VPWR VGND sg13g2_decap_8
XFILLER_8_549 VPWR VGND sg13g2_decap_8
XFILLER_4_711 VPWR VGND sg13g2_decap_8
XFILLER_4_788 VPWR VGND sg13g2_decap_8
XFILLER_10_92 VPWR VGND sg13g2_decap_4
XFILLER_48_954 VPWR VGND sg13g2_decap_8
XFILLER_0_994 VPWR VGND sg13g2_decap_8
XFILLER_47_464 VPWR VGND sg13g2_decap_8
Xu_ppwm_u_mem__1152_ net159 VGND VPWR u_ppwm_u_mem__1152_/D hold65/A clknet_5_3__leaf_clk
+ sg13g2_dfrbpq_1
XFILLER_35_604 VPWR VGND sg13g2_decap_8
Xu_ppwm_u_mem__1083_ net477 VPWR u_ppwm_u_mem__1084_/A VGND net622 u_ppwm_u_mem__1081_/D
+ sg13g2_o21ai_1
XFILLER_37_1001 VPWR VGND sg13g2_decap_8
XFILLER_16_884 VPWR VGND sg13g2_decap_8
XFILLER_31_810 VPWR VGND sg13g2_decap_8
XFILLER_31_887 VPWR VGND sg13g2_decap_8
Xu_ppwm_u_mem__0936_ VGND VPWR u_ppwm_u_mem__0664_/Y net418 u_ppwm_u_mem__1138_/D
+ u_ppwm_u_mem__0935_/Y sg13g2_a21oi_1
Xu_ppwm_u_ex__0724_ u_ppwm_u_ex__0727_/A u_ppwm_u_ex__0724_/B u_ppwm_u_ex__0724_/C
+ u_ppwm_u_ex__0724_/Y VPWR VGND sg13g2_nor3_1
Xu_ppwm_u_global_counter__175__67 VPWR VGND net67 sg13g2_tiehi
Xu_ppwm_u_mem__0867_ net490 VPWR u_ppwm_u_mem__0867_/Y VGND hold176/A net400 sg13g2_o21ai_1
XFILLER_7_582 VPWR VGND sg13g2_decap_8
Xu_ppwm_u_ex__0655_ u_ppwm_u_ex__0655_/A u_ppwm_u_ex__0655_/B u_ppwm_u_ex__1119_/D
+ VPWR VGND sg13g2_nor2_1
Xu_ppwm_u_mem__0798_ net461 u_ppwm_u_mem__0797_/X u_ppwm_u_mem__0796_/X u_ppwm_u_mem__0794_/X
+ u_ppwm_u_mem__0795_/X net456 u_ppwm_u_mem__0799_/B VPWR VGND sg13g2_mux4_1
Xu_ppwm_u_ex__0586_ VPWR u_ppwm_u_ex__0586_/Y net454 VGND sg13g2_inv_1
XFILLER_44_1027 VPWR VGND sg13g2_fill_2
XFILLER_32_0 VPWR VGND sg13g2_decap_8
XFILLER_39_976 VPWR VGND sg13g2_decap_8
Xu_ppwm_u_global_counter__127_ VGND VPWR net424 u_ppwm_u_global_counter__129_/A hold235/A
+ net617 sg13g2_a21oi_1
Xu_ppwm_u_ex__1138_ net53 VGND VPWR u_ppwm_u_ex__1138_/D hold302/A clknet_5_7__leaf_clk
+ sg13g2_dfrbpq_1
XFILLER_26_648 VPWR VGND sg13g2_decap_8
XFILLER_38_497 VPWR VGND sg13g2_decap_8
Xu_ppwm_u_ex__1069_ u_ppwm_u_ex__1077_/B u_ppwm_u_ex__1069_/B u_ppwm_u_ex__1073_/B
+ VPWR VGND sg13g2_nor2_1
XFILLER_41_629 VPWR VGND sg13g2_decap_8
XFILLER_15_59 VPWR VGND sg13g2_fill_2
XFILLER_22_854 VPWR VGND sg13g2_decap_8
XFILLER_21_364 VPWR VGND sg13g2_decap_8
XFILLER_0_213 VPWR VGND sg13g2_decap_4
XFILLER_1_769 VPWR VGND sg13g2_decap_8
XFILLER_5_1021 VPWR VGND sg13g2_decap_8
XFILLER_45_935 VPWR VGND sg13g2_decap_8
XFILLER_17_615 VPWR VGND sg13g2_decap_8
XFILLER_29_486 VPWR VGND sg13g2_decap_8
XFILLER_44_467 VPWR VGND sg13g2_decap_8
XFILLER_13_854 VPWR VGND sg13g2_decap_8
XFILLER_9_836 VPWR VGND sg13g2_decap_8
XFILLER_40_695 VPWR VGND sg13g2_decap_8
Xu_ppwm_u_mem__0721_ net465 hold165/A hold117/A hold194/A hold120/A net457 u_ppwm_u_mem__0722_/B
+ VPWR VGND sg13g2_mux4_1
Xu_ppwm_u_global_counter__172__59 VPWR VGND net59 sg13g2_tiehi
XFILLER_4_585 VPWR VGND sg13g2_decap_8
Xu_ppwm_u_mem__0652_ VPWR u_ppwm_u_mem__0652_/Y net237 VGND sg13g2_inv_1
XFILLER_0_791 VPWR VGND sg13g2_decap_8
XFILLER_48_751 VPWR VGND sg13g2_decap_8
Xu_ppwm_u_mem__1204_ net78 VGND VPWR u_ppwm_u_mem__1204_/D hold248/A clknet_5_2__leaf_clk
+ sg13g2_dfrbpq_2
XFILLER_36_935 VPWR VGND sg13g2_decap_8
Xu_ppwm_u_mem__1135_ net81 VGND VPWR net325 hold107/A clknet_5_30__leaf_clk sg13g2_dfrbpq_1
Xu_ppwm_u_mem__1066_ hold252/A hold243/A net311 u_ppwm_u_mem__1066_/Y VPWR VGND sg13g2_nand3_1
Xheichips25_ppwm_7 VPWR VGND uio_oe[3] sg13g2_tielo
XFILLER_16_681 VPWR VGND sg13g2_decap_8
XFILLER_31_684 VPWR VGND sg13g2_decap_8
Xu_ppwm_u_mem__1163__116 VPWR VGND net116 sg13g2_tiehi
XFILLER_11_1004 VPWR VGND sg13g2_decap_8
Xu_ppwm_u_mem__0919_ net505 VPWR u_ppwm_u_mem__0919_/Y VGND net314 net418 sg13g2_o21ai_1
Xu_ppwm_u_ex__0707_ u_ppwm_u_ex__0706_/Y VPWR u_ppwm_u_ex__0707_/Y VGND net446 u_ppwm_u_ex__0599_/Y
+ sg13g2_o21ai_1
Xhold302 hold302/A VPWR VGND net685 sg13g2_dlygate4sd3_1
Xu_ppwm_u_ex__0638_ VGND VPWR net475 u_ppwm_u_ex__0637_/Y u_ppwm_u_ex__0639_/C net458
+ sg13g2_a21oi_1
XFILLER_39_773 VPWR VGND sg13g2_decap_8
XFILLER_27_946 VPWR VGND sg13g2_decap_8
XFILLER_26_25 VPWR VGND sg13g2_fill_2
XFILLER_26_445 VPWR VGND sg13g2_decap_8
XFILLER_42_916 VPWR VGND sg13g2_decap_8
XFILLER_14_618 VPWR VGND sg13g2_decap_8
XFILLER_13_117 VPWR VGND sg13g2_fill_1
XFILLER_42_35 VPWR VGND sg13g2_fill_2
XFILLER_22_651 VPWR VGND sg13g2_decap_8
XFILLER_10_824 VPWR VGND sg13g2_decap_8
XFILLER_6_806 VPWR VGND sg13g2_decap_8
XFILLER_3_18 VPWR VGND sg13g2_fill_1
XFILLER_1_566 VPWR VGND sg13g2_decap_8
XFILLER_49_537 VPWR VGND sg13g2_decap_8
XFILLER_18_935 VPWR VGND sg13g2_decap_8
XFILLER_45_732 VPWR VGND sg13g2_decap_8
XFILLER_17_423 VPWR VGND sg13g2_fill_1
XFILLER_17_489 VPWR VGND sg13g2_decap_8
XFILLER_32_404 VPWR VGND sg13g2_decap_4
XFILLER_33_949 VPWR VGND sg13g2_decap_8
XFILLER_13_651 VPWR VGND sg13g2_decap_8
XFILLER_34_1004 VPWR VGND sg13g2_decap_8
XFILLER_41_993 VPWR VGND sg13g2_decap_8
XFILLER_9_633 VPWR VGND sg13g2_decap_8
XFILLER_40_492 VPWR VGND sg13g2_decap_8
XFILLER_8_154 VPWR VGND sg13g2_fill_1
Xu_ppwm_u_mem__0704_ VPWR u_ppwm_u_mem__0704_/Y net523 VGND sg13g2_inv_1
Xu_ppwm_u_mem__0635_ VPWR u_ppwm_u_mem__0635_/Y net323 VGND sg13g2_inv_1
XFILLER_36_732 VPWR VGND sg13g2_decap_8
Xu_ppwm_u_mem__1118_ net115 VGND VPWR net255 hold37/A clknet_5_14__leaf_clk sg13g2_dfrbpq_1
XFILLER_23_448 VPWR VGND sg13g2_decap_8
Xu_ppwm_u_mem__1049_ net499 VPWR u_ppwm_u_mem__1049_/Y VGND hold44/A net406 sg13g2_o21ai_1
Xhold110 hold110/A VPWR VGND net327 sg13g2_dlygate4sd3_1
Xhold143 hold143/A VPWR VGND net526 sg13g2_dlygate4sd3_1
Xhold121 hold121/A VPWR VGND net338 sg13g2_dlygate4sd3_1
Xhold132 hold132/A VPWR VGND net515 sg13g2_dlygate4sd3_1
Xhold176 hold176/A VPWR VGND net559 sg13g2_dlygate4sd3_1
Xhold165 hold165/A VPWR VGND net548 sg13g2_dlygate4sd3_1
Xhold154 hold154/A VPWR VGND net537 sg13g2_dlygate4sd3_1
Xu_ppwm_u_mem__1098__154 VPWR VGND net154 sg13g2_tiehi
Xhold198 hold198/A VPWR VGND net581 sg13g2_dlygate4sd3_1
Xhold187 hold187/A VPWR VGND net570 sg13g2_dlygate4sd3_1
XFILLER_39_570 VPWR VGND sg13g2_decap_8
Xu_ppwm_u_mem__1173__76 VPWR VGND net76 sg13g2_tiehi
XFILLER_37_35 VPWR VGND sg13g2_fill_2
XFILLER_27_743 VPWR VGND sg13g2_decap_8
XFILLER_42_713 VPWR VGND sg13g2_decap_8
XFILLER_15_927 VPWR VGND sg13g2_decap_8
XFILLER_6_603 VPWR VGND sg13g2_decap_8
XFILLER_10_621 VPWR VGND sg13g2_decap_8
XFILLER_10_698 VPWR VGND sg13g2_decap_8
XFILLER_2_886 VPWR VGND sg13g2_decap_8
XFILLER_1_363 VPWR VGND sg13g2_decap_8
XFILLER_37_518 VPWR VGND sg13g2_decap_8
XFILLER_18_732 VPWR VGND sg13g2_decap_8
XFILLER_33_746 VPWR VGND sg13g2_decap_8
Xu_ppwm_u_ex__0972_ u_ppwm_u_ex__0971_/Y u_ppwm_u_ex__0970_/Y net351 u_ppwm_u_ex__0973_/C
+ VPWR VGND sg13g2_a21o_1
XFILLER_14_982 VPWR VGND sg13g2_decap_8
XFILLER_32_278 VPWR VGND sg13g2_decap_8
XFILLER_41_790 VPWR VGND sg13g2_decap_8
Xu_ppwm_u_mem__0618_ VPWR u_ppwm_u_mem__0618_/Y net260 VGND sg13g2_inv_1
Xheichips25_ppwm_17 VPWR VGND uio_out[5] sg13g2_tielo
XFILLER_28_518 VPWR VGND sg13g2_decap_8
XFILLER_23_201 VPWR VGND sg13g2_decap_8
XFILLER_12_919 VPWR VGND sg13g2_decap_8
XFILLER_24_768 VPWR VGND sg13g2_decap_8
XFILLER_11_418 VPWR VGND sg13g2_fill_1
XFILLER_17_1021 VPWR VGND sg13g2_decap_8
XFILLER_20_930 VPWR VGND sg13g2_decap_8
Xfanout431 net681 net431 VPWR VGND sg13g2_buf_8
Xfanout420 net421 net420 VPWR VGND sg13g2_buf_8
Xfanout464 net474 net464 VPWR VGND sg13g2_buf_8
Xfanout442 net680 net442 VPWR VGND sg13g2_buf_8
Xfanout475 net616 net475 VPWR VGND sg13g2_buf_8
Xfanout453 net454 net453 VPWR VGND sg13g2_buf_2
XFILLER_19_529 VPWR VGND sg13g2_decap_8
Xfanout497 rst_n net497 VPWR VGND sg13g2_buf_8
Xfanout486 net492 net486 VPWR VGND sg13g2_buf_8
XFILLER_47_849 VPWR VGND sg13g2_decap_8
XFILLER_27_540 VPWR VGND sg13g2_decap_8
XFILLER_42_510 VPWR VGND sg13g2_decap_8
XFILLER_14_212 VPWR VGND sg13g2_fill_1
XFILLER_15_724 VPWR VGND sg13g2_decap_8
XFILLER_42_587 VPWR VGND sg13g2_decap_8
XFILLER_30_738 VPWR VGND sg13g2_decap_8
Xu_ppwm_u_pwm__211_ u_ppwm_u_pwm__211_/Y hold169/A hold213/A VPWR VGND sg13g2_nand2b_1
XFILLER_11_941 VPWR VGND sg13g2_decap_8
XFILLER_6_400 VPWR VGND sg13g2_decap_8
Xu_ppwm_u_ex__1141__38 VPWR VGND net38 sg13g2_tiehi
XFILLER_7_967 VPWR VGND sg13g2_decap_8
Xu_ppwm_u_pwm__142_ hold213/A hold205/A hold229/A u_ppwm_u_pwm__146_/A VPWR VGND sg13g2_nand3_1
XFILLER_10_495 VPWR VGND sg13g2_decap_8
XFILLER_6_477 VPWR VGND sg13g2_decap_8
XFILLER_2_683 VPWR VGND sg13g2_decap_8
XFILLER_36_7 VPWR VGND sg13g2_decap_8
Xu_ppwm_u_global_counter__160_ net57 VGND VPWR net615 fanout428/A clknet_5_21__leaf_clk
+ sg13g2_dfrbpq_2
XFILLER_38_805 VPWR VGND sg13g2_decap_8
Xu_ppwm_u_global_counter__091_ u_ppwm_u_global_counter__155_/B net637 VPWR VGND sg13g2_inv_2
XFILLER_46_860 VPWR VGND sg13g2_decap_8
XFILLER_33_543 VPWR VGND sg13g2_decap_8
Xu_ppwm_u_ex__0955_ VGND VPWR u_ppwm_u_ex__0946_/X u_ppwm_u_ex__0947_/Y u_ppwm_u_ex__0957_/A
+ u_ppwm_u_ex__0954_/Y sg13g2_a21oi_1
Xu_ppwm_u_ex__0886_ u_ppwm_u_ex__0886_/Y net444 net364 VPWR VGND sg13g2_xnor2_1
XFILLER_47_1003 VPWR VGND sg13g2_decap_8
XFILLER_0_609 VPWR VGND sg13g2_decap_8
XFILLER_37_882 VPWR VGND sg13g2_decap_8
XFILLER_34_36 VPWR VGND sg13g2_fill_2
XFILLER_12_716 VPWR VGND sg13g2_decap_8
XFILLER_24_565 VPWR VGND sg13g2_decap_8
Xclkload2 clknet_5_4__leaf_clk clkload2/X VPWR VGND sg13g2_buf_1
Xu_ppwm_u_ex__1123__27 VPWR VGND net27 sg13g2_tiehi
XFILLER_3_469 VPWR VGND sg13g2_decap_8
XFILLER_47_646 VPWR VGND sg13g2_decap_8
XFILLER_15_521 VPWR VGND sg13g2_decap_8
XFILLER_28_882 VPWR VGND sg13g2_decap_8
XFILLER_43_841 VPWR VGND sg13g2_decap_8
XFILLER_42_351 VPWR VGND sg13g2_fill_1
XFILLER_15_598 VPWR VGND sg13g2_decap_8
XFILLER_30_535 VPWR VGND sg13g2_decap_8
Xu_ppwm_u_ex__0740_ u_ppwm_u_ex__0742_/B net434 net422 VPWR VGND sg13g2_nand2b_1
XFILLER_24_80 VPWR VGND sg13g2_fill_2
Xu_ppwm_u_mem__0952_ VGND VPWR u_ppwm_u_mem__0656_/Y net383 u_ppwm_u_mem__1146_/D
+ u_ppwm_u_mem__0951_/Y sg13g2_a21oi_1
Xu_ppwm_u_ex__1114__49 VPWR VGND net49 sg13g2_tiehi
Xu_ppwm_u_mem__0883_ net491 VPWR u_ppwm_u_mem__0883_/Y VGND net291 net400 sg13g2_o21ai_1
Xu_ppwm_u_ex__0671_ u_ppwm_u_ex__0671_/A u_ppwm_u_ex__0671_/B u_ppwm_u_ex__0671_/X
+ VPWR VGND sg13g2_and2_1
XFILLER_7_764 VPWR VGND sg13g2_decap_8
XFILLER_2_480 VPWR VGND sg13g2_decap_8
XFILLER_38_602 VPWR VGND sg13g2_decap_8
Xu_ppwm_u_global_counter__143_ net480 VPWR u_ppwm_u_global_counter__143_/Y VGND net423
+ u_ppwm_u_global_counter__156_/C sg13g2_o21ai_1
Xu_ppwm_u_ex__1085_ net497 VPWR u_ppwm_u_ex__1085_/Y VGND net658 net341 sg13g2_o21ai_1
XFILLER_38_679 VPWR VGND sg13g2_decap_8
XFILLER_19_893 VPWR VGND sg13g2_decap_8
XFILLER_37_167 VPWR VGND sg13g2_decap_8
XFILLER_33_362 VPWR VGND sg13g2_decap_4
XFILLER_34_885 VPWR VGND sg13g2_decap_8
Xu_ppwm_u_global_counter__178__65 VPWR VGND net65 sg13g2_tiehi
XFILLER_14_1024 VPWR VGND sg13g2_decap_4
XFILLER_21_568 VPWR VGND sg13g2_decap_8
Xu_ppwm_u_ex__0938_ hold256/A net355 u_ppwm_u_ex__0938_/X VPWR VGND sg13g2_and2_1
Xu_ppwm_u_ex__0869_ u_ppwm_u_ex__0869_/Y u_ppwm_u_ex__0888_/B u_ppwm_u_ex__0888_/C
+ VPWR VGND sg13g2_nand2_1
XFILLER_0_406 VPWR VGND sg13g2_decap_8
Xhold14 hold14/A VPWR VGND net231 sg13g2_dlygate4sd3_1
Xhold47 hold47/A VPWR VGND net264 sg13g2_dlygate4sd3_1
XFILLER_29_47 VPWR VGND sg13g2_fill_1
Xhold25 hold25/A VPWR VGND net242 sg13g2_dlygate4sd3_1
Xhold36 hold36/A VPWR VGND net253 sg13g2_dlygate4sd3_1
Xhold58 hold58/A VPWR VGND net275 sg13g2_dlygate4sd3_1
Xhold69 hold69/A VPWR VGND net286 sg13g2_dlygate4sd3_1
XFILLER_29_668 VPWR VGND sg13g2_decap_8
XFILLER_45_35 VPWR VGND sg13g2_fill_1
XFILLER_44_649 VPWR VGND sg13g2_decap_8
XFILLER_43_104 VPWR VGND sg13g2_fill_2
XFILLER_28_178 VPWR VGND sg13g2_fill_2
XFILLER_25_830 VPWR VGND sg13g2_decap_8
XFILLER_40_800 VPWR VGND sg13g2_decap_8
XFILLER_12_513 VPWR VGND sg13g2_decap_8
XFILLER_40_877 VPWR VGND sg13g2_decap_8
XFILLER_8_528 VPWR VGND sg13g2_decap_8
XFILLER_3_211 VPWR VGND sg13g2_fill_2
XFILLER_4_767 VPWR VGND sg13g2_decap_8
XFILLER_3_222 VPWR VGND sg13g2_fill_2
XFILLER_10_82 VPWR VGND sg13g2_decap_4
XFILLER_3_255 VPWR VGND sg13g2_fill_2
XFILLER_0_973 VPWR VGND sg13g2_decap_8
XFILLER_48_933 VPWR VGND sg13g2_decap_8
XFILLER_47_443 VPWR VGND sg13g2_decap_8
Xu_ppwm_u_mem__1151_ net163 VGND VPWR u_ppwm_u_mem__1151_/D hold117/A clknet_5_24__leaf_clk
+ sg13g2_dfrbpq_1
Xu_ppwm_u_mem__1082_ net622 VPWR u_ppwm_u_mem__1082_/Y VGND u_ppwm_u_mem__1081_/B
+ u_ppwm_u_mem__1081_/D sg13g2_o21ai_1
XFILLER_16_863 VPWR VGND sg13g2_decap_8
XFILLER_31_866 VPWR VGND sg13g2_decap_8
XFILLER_30_387 VPWR VGND sg13g2_fill_2
Xu_ppwm_u_mem__0935_ net505 VPWR u_ppwm_u_mem__0935_/Y VGND net265 net419 sg13g2_o21ai_1
Xu_ppwm_u_ex__0723_ u_ppwm_u_ex__0727_/B VPWR u_ppwm_u_ex__0724_/C VGND u_ppwm_u_ex__0896_/A
+ hold281/A sg13g2_o21ai_1
Xu_ppwm_u_mem__0866_ VGND VPWR u_ppwm_u_mem__0699_/Y net396 hold143/A u_ppwm_u_mem__0865_/Y
+ sg13g2_a21oi_1
XFILLER_7_561 VPWR VGND sg13g2_decap_8
Xu_ppwm_u_ex__0654_ net494 VPWR u_ppwm_u_ex__0655_/B VGND net451 net475 sg13g2_o21ai_1
Xu_ppwm_u_mem__0797_ hold121/A hold112/A net464 u_ppwm_u_mem__0797_/X VPWR VGND sg13g2_mux2_1
Xu_ppwm_u_ex__0585_ u_ppwm_u_ex__0995_/A net475 VPWR VGND sg13g2_inv_2
XFILLER_44_1006 VPWR VGND sg13g2_decap_8
XFILLER_39_955 VPWR VGND sg13g2_decap_8
Xu_ppwm_u_global_counter__126_ net429 net666 u_ppwm_u_global_counter__168_/D VPWR
+ VGND sg13g2_nor2_1
Xu_ppwm_u_ex__1137_ net34 VGND VPWR u_ppwm_u_ex__1137_/D hold261/A clknet_5_23__leaf_clk
+ sg13g2_dfrbpq_2
XFILLER_26_627 VPWR VGND sg13g2_decap_8
XFILLER_38_476 VPWR VGND sg13g2_decap_8
XFILLER_19_690 VPWR VGND sg13g2_decap_8
Xu_ppwm_u_ex__1068_ net350 VPWR u_ppwm_u_ex__1069_/B VGND u_ppwm_u_ex__1087_/A u_ppwm_u_ex__1067_/B
+ sg13g2_o21ai_1
XFILLER_41_608 VPWR VGND sg13g2_decap_8
XFILLER_40_107 VPWR VGND sg13g2_fill_2
XFILLER_22_833 VPWR VGND sg13g2_decap_8
XFILLER_34_682 VPWR VGND sg13g2_decap_8
XFILLER_21_354 VPWR VGND sg13g2_fill_1
XFILLER_1_748 VPWR VGND sg13g2_decap_8
XFILLER_49_719 VPWR VGND sg13g2_decap_8
XFILLER_5_1000 VPWR VGND sg13g2_decap_8
XFILLER_45_914 VPWR VGND sg13g2_decap_8
XFILLER_16_115 VPWR VGND sg13g2_fill_2
XFILLER_16_126 VPWR VGND sg13g2_fill_2
XFILLER_13_833 VPWR VGND sg13g2_decap_8
XFILLER_9_815 VPWR VGND sg13g2_decap_8
XFILLER_40_674 VPWR VGND sg13g2_decap_8
Xu_ppwm_u_mem__0720_ hold252/A net626 u_ppwm_u_mem__0720_/C u_ppwm_u_pwm__154_/A VGND
+ VPWR u_ppwm_u_mem__1080_/A sg13g2_nor4_2
Xu_ppwm_u_mem__0651_ VPWR u_ppwm_u_mem__0651_/Y net334 VGND sg13g2_inv_1
XFILLER_4_564 VPWR VGND sg13g2_decap_8
XFILLER_48_730 VPWR VGND sg13g2_decap_8
XFILLER_39_229 VPWR VGND sg13g2_decap_8
XFILLER_39_218 VPWR VGND sg13g2_fill_1
XFILLER_0_770 VPWR VGND sg13g2_decap_8
Xu_ppwm_u_mem__1203_ net110 VGND VPWR net562 hold177/A clknet_5_3__leaf_clk sg13g2_dfrbpq_1
XFILLER_47_262 VPWR VGND sg13g2_fill_2
XFILLER_36_914 VPWR VGND sg13g2_decap_8
Xu_ppwm_u_mem__1134_ net83 VGND VPWR u_ppwm_u_mem__1134_/D hold147/A clknet_5_30__leaf_clk
+ sg13g2_dfrbpq_1
Xu_ppwm_u_mem__1065_ u_ppwm_u_mem__1081_/A net636 u_ppwm_u_mem__1201_/D VPWR VGND
+ sg13g2_nor2_1
XFILLER_16_660 VPWR VGND sg13g2_decap_8
Xheichips25_ppwm_8 VPWR VGND uio_oe[4] sg13g2_tielo
XFILLER_22_129 VPWR VGND sg13g2_decap_8
XFILLER_31_663 VPWR VGND sg13g2_decap_8
XFILLER_30_162 VPWR VGND sg13g2_fill_2
Xu_ppwm_u_mem__0918_ VGND VPWR u_ppwm_u_mem__0673_/Y net416 u_ppwm_u_mem__1129_/D
+ u_ppwm_u_mem__0917_/Y sg13g2_a21oi_1
XFILLER_8_892 VPWR VGND sg13g2_decap_8
Xu_ppwm_u_ex__0706_ u_ppwm_u_ex__0706_/Y hold222/A hold278/A VPWR VGND sg13g2_nand2b_1
Xhold303 hold303/A VPWR VGND net686 sg13g2_dlygate4sd3_1
Xu_ppwm_u_mem__0849_ net486 VPWR u_ppwm_u_mem__0849_/Y VGND net239 net395 sg13g2_o21ai_1
Xu_ppwm_u_ex__0637_ u_ppwm_u_ex__0637_/Y u_ppwm_u_ex__0637_/A u_ppwm_u_ex__0652_/B
+ VPWR VGND sg13g2_nand2_1
XFILLER_39_752 VPWR VGND sg13g2_decap_8
XFILLER_26_402 VPWR VGND sg13g2_decap_8
XFILLER_27_925 VPWR VGND sg13g2_decap_8
Xu_ppwm_u_global_counter__109_ u_ppwm_u_global_counter__120_/B u_ppwm_u_global_counter__120_/C
+ u_ppwm_u_global_counter__116_/C VPWR VGND sg13g2_nor2_2
XFILLER_26_424 VPWR VGND sg13g2_decap_8
XFILLER_10_803 VPWR VGND sg13g2_decap_8
XFILLER_22_630 VPWR VGND sg13g2_decap_8
XFILLER_21_195 VPWR VGND sg13g2_fill_2
XFILLER_1_545 VPWR VGND sg13g2_decap_8
XFILLER_27_1023 VPWR VGND sg13g2_decap_4
XFILLER_49_516 VPWR VGND sg13g2_decap_8
XFILLER_45_711 VPWR VGND sg13g2_decap_8
XFILLER_18_914 VPWR VGND sg13g2_decap_8
XFILLER_45_788 VPWR VGND sg13g2_decap_8
XFILLER_44_254 VPWR VGND sg13g2_fill_2
XFILLER_44_243 VPWR VGND sg13g2_decap_8
XFILLER_17_468 VPWR VGND sg13g2_decap_8
XFILLER_33_928 VPWR VGND sg13g2_decap_8
XFILLER_26_991 VPWR VGND sg13g2_decap_8
XFILLER_13_630 VPWR VGND sg13g2_decap_8
XFILLER_16_92 VPWR VGND sg13g2_decap_8
XFILLER_41_972 VPWR VGND sg13g2_decap_8
XFILLER_40_471 VPWR VGND sg13g2_decap_8
XFILLER_9_612 VPWR VGND sg13g2_decap_8
XFILLER_12_195 VPWR VGND sg13g2_fill_1
XFILLER_9_689 VPWR VGND sg13g2_decap_8
Xu_ppwm_u_mem__0703_ VPWR u_ppwm_u_mem__0703_/Y net329 VGND sg13g2_inv_1
XFILLER_5_895 VPWR VGND sg13g2_decap_8
Xu_ppwm_u_mem__0634_ VPWR u_ppwm_u_mem__0634_/Y net249 VGND sg13g2_inv_1
XFILLER_36_711 VPWR VGND sg13g2_decap_8
Xu_ppwm_u_mem__1117_ net117 VGND VPWR u_ppwm_u_mem__1117_/D hold152/A clknet_5_26__leaf_clk
+ sg13g2_dfrbpq_1
XFILLER_35_243 VPWR VGND sg13g2_fill_1
XFILLER_36_788 VPWR VGND sg13g2_decap_8
XFILLER_23_416 VPWR VGND sg13g2_fill_1
Xu_ppwm_u_mem__1048_ VGND VPWR u_ppwm_u_mem__0608_/Y net406 u_ppwm_u_mem__1194_/D
+ u_ppwm_u_mem__1047_/Y sg13g2_a21oi_1
Xhold100 hold100/A VPWR VGND net317 sg13g2_dlygate4sd3_1
Xhold111 hold111/A VPWR VGND net328 sg13g2_dlygate4sd3_1
Xhold144 hold144/A VPWR VGND net527 sg13g2_dlygate4sd3_1
Xhold133 hold133/A VPWR VGND net516 sg13g2_dlygate4sd3_1
Xhold122 hold122/A VPWR VGND net339 sg13g2_dlygate4sd3_1
Xhold166 hold166/A VPWR VGND net549 sg13g2_dlygate4sd3_1
Xhold155 hold155/A VPWR VGND net538 sg13g2_dlygate4sd3_1
Xhold177 hold177/A VPWR VGND net560 sg13g2_dlygate4sd3_1
Xhold188 hold188/A VPWR VGND net571 sg13g2_dlygate4sd3_1
Xhold199 hold199/A VPWR VGND net582 sg13g2_dlygate4sd3_1
XFILLER_37_14 VPWR VGND sg13g2_decap_8
XFILLER_27_722 VPWR VGND sg13g2_decap_8
XFILLER_14_405 VPWR VGND sg13g2_decap_8
XFILLER_15_906 VPWR VGND sg13g2_decap_8
XFILLER_41_224 VPWR VGND sg13g2_fill_1
XFILLER_27_799 VPWR VGND sg13g2_decap_8
XFILLER_42_769 VPWR VGND sg13g2_decap_8
XFILLER_41_235 VPWR VGND sg13g2_fill_2
XFILLER_10_600 VPWR VGND sg13g2_decap_8
XFILLER_23_994 VPWR VGND sg13g2_decap_8
XFILLER_10_677 VPWR VGND sg13g2_decap_8
Xu_ppwm_u_mem__1146__178 VPWR VGND net178 sg13g2_tiehi
XFILLER_6_659 VPWR VGND sg13g2_decap_8
XFILLER_2_865 VPWR VGND sg13g2_decap_8
XFILLER_49_302 VPWR VGND sg13g2_decap_8
XFILLER_18_711 VPWR VGND sg13g2_decap_8
XFILLER_18_788 VPWR VGND sg13g2_decap_8
XFILLER_45_585 VPWR VGND sg13g2_decap_8
Xu_ppwm_u_ex__1129__44 VPWR VGND net44 sg13g2_tiehi
XFILLER_33_725 VPWR VGND sg13g2_decap_8
Xu_ppwm_u_ex__0971_ u_ppwm_u_ex__0971_/Y net355 hold281/A net357 net424 VPWR VGND
+ sg13g2_a22oi_1
XFILLER_14_961 VPWR VGND sg13g2_decap_8
XFILLER_20_408 VPWR VGND sg13g2_decap_4
XFILLER_9_486 VPWR VGND sg13g2_decap_8
XFILLER_5_692 VPWR VGND sg13g2_decap_8
Xu_ppwm_u_mem__0617_ VPWR u_ppwm_u_mem__0617_/Y net258 VGND sg13g2_inv_1
XFILLER_4_84 VPWR VGND sg13g2_decap_4
Xheichips25_ppwm_18 VPWR VGND uio_out[6] sg13g2_tielo
XFILLER_49_880 VPWR VGND sg13g2_decap_8
Xu_ppwm_u_pwm__240__197 VPWR VGND net197 sg13g2_tiehi
XFILLER_36_585 VPWR VGND sg13g2_decap_8
XFILLER_17_1000 VPWR VGND sg13g2_decap_8
XFILLER_24_747 VPWR VGND sg13g2_decap_8
Xu_ppwm_u_ex__1135__47 VPWR VGND net47 sg13g2_tiehi
Xclkbuf_5_18__f_clk clknet_4_9_0_clk clknet_5_18__leaf_clk VPWR VGND sg13g2_buf_8
XFILLER_20_986 VPWR VGND sg13g2_decap_8
Xfanout432 hold302/A net432 VPWR VGND sg13g2_buf_8
Xfanout421 fanout421/A net421 VPWR VGND sg13g2_buf_8
Xfanout410 net421 net410 VPWR VGND sg13g2_buf_8
Xfanout443 net677 net443 VPWR VGND sg13g2_buf_8
Xfanout465 net474 net465 VPWR VGND sg13g2_buf_8
Xfanout454 net456 net454 VPWR VGND sg13g2_buf_8
XFILLER_47_828 VPWR VGND sg13g2_decap_8
XFILLER_19_508 VPWR VGND sg13g2_decap_8
Xfanout476 net493 net476 VPWR VGND sg13g2_buf_8
Xfanout487 net488 net487 VPWR VGND sg13g2_buf_8
Xfanout498 net502 net498 VPWR VGND sg13g2_buf_8
XFILLER_46_338 VPWR VGND sg13g2_decap_8
XFILLER_15_703 VPWR VGND sg13g2_decap_8
XFILLER_27_596 VPWR VGND sg13g2_decap_8
XFILLER_42_566 VPWR VGND sg13g2_decap_8
XFILLER_14_257 VPWR VGND sg13g2_decap_8
XFILLER_30_717 VPWR VGND sg13g2_decap_8
Xu_ppwm_u_pwm__210_ u_ppwm_u_pwm__210_/Y hold6/A hold205/A VPWR VGND sg13g2_nand2b_1
XFILLER_11_920 VPWR VGND sg13g2_decap_8
XFILLER_23_791 VPWR VGND sg13g2_decap_8
XFILLER_7_946 VPWR VGND sg13g2_decap_8
Xu_ppwm_u_pwm__141_ u_ppwm_u_pwm__175_/A net476 VPWR VGND sg13g2_inv_2
XFILLER_10_474 VPWR VGND sg13g2_decap_8
XFILLER_11_997 VPWR VGND sg13g2_decap_8
XFILLER_6_456 VPWR VGND sg13g2_decap_8
XFILLER_2_662 VPWR VGND sg13g2_decap_8
XFILLER_49_110 VPWR VGND sg13g2_fill_2
XFILLER_49_187 VPWR VGND sg13g2_decap_4
XFILLER_49_176 VPWR VGND sg13g2_fill_2
Xu_ppwm_u_mem__1137__77 VPWR VGND net77 sg13g2_tiehi
Xu_ppwm_u_global_counter__090_ VPWR u_ppwm_u_global_counter__155_/A net664 VGND sg13g2_inv_1
XFILLER_18_585 VPWR VGND sg13g2_decap_8
XFILLER_33_522 VPWR VGND sg13g2_decap_8
Xu_ppwm_u_ex__0954_ u_ppwm_u_ex__1083_/A u_ppwm_u_ex__0954_/C net344 u_ppwm_u_ex__0954_/Y
+ VPWR VGND sg13g2_nand3_1
XFILLER_33_599 VPWR VGND sg13g2_decap_8
XFILLER_9_250 VPWR VGND sg13g2_decap_4
Xu_ppwm_u_ex__0885_ u_ppwm_u_ex__0885_/Y net444 net364 VPWR VGND sg13g2_nand2_1
Xu_ppwm_u_pwm__242__215 VPWR VGND net215 sg13g2_tiehi
XFILLER_37_861 VPWR VGND sg13g2_decap_8
XFILLER_24_544 VPWR VGND sg13g2_decap_8
XFILLER_36_393 VPWR VGND sg13g2_fill_1
XFILLER_11_227 VPWR VGND sg13g2_fill_1
Xclkload3 clknet_5_6__leaf_clk clkload3/X VPWR VGND sg13g2_buf_1
XFILLER_20_783 VPWR VGND sg13g2_decap_8
XFILLER_4_949 VPWR VGND sg13g2_decap_8
XFILLER_3_448 VPWR VGND sg13g2_decap_8
XFILLER_47_625 VPWR VGND sg13g2_decap_8
XFILLER_46_157 VPWR VGND sg13g2_fill_2
XFILLER_28_861 VPWR VGND sg13g2_decap_8
XFILLER_43_820 VPWR VGND sg13g2_decap_8
XFILLER_15_500 VPWR VGND sg13g2_decap_8
XFILLER_43_897 VPWR VGND sg13g2_decap_8
XFILLER_15_577 VPWR VGND sg13g2_decap_8
XFILLER_30_514 VPWR VGND sg13g2_decap_8
Xu_ppwm_u_mem__0951_ net483 VPWR u_ppwm_u_mem__0951_/Y VGND net554 net383 sg13g2_o21ai_1
Xu_ppwm_u_mem__0882_ VGND VPWR u_ppwm_u_mem__0691_/Y net400 u_ppwm_u_mem__1111_/D
+ u_ppwm_u_mem__0881_/Y sg13g2_a21oi_1
XFILLER_7_743 VPWR VGND sg13g2_decap_8
XFILLER_11_794 VPWR VGND sg13g2_decap_8
Xu_ppwm_u_ex__0670_ u_ppwm_u_ex__0671_/B hold284/A u_ppwm_u_ex__0721_/A net424 u_ppwm_u_ex__0896_/A
+ VPWR VGND sg13g2_a22oi_1
Xu_ppwm_u_global_counter__142_ net429 net606 u_ppwm_u_global_counter__156_/C hold224/A
+ VPWR VGND sg13g2_nor3_1
Xu_ppwm_u_ex__1084_ u_ppwm_u_ex__1084_/A u_ppwm_u_ex__1084_/B u_ppwm_u_ex__1084_/Y
+ VPWR VGND sg13g2_nor2_1
XFILLER_26_809 VPWR VGND sg13g2_decap_8
XFILLER_38_658 VPWR VGND sg13g2_decap_8
XFILLER_19_872 VPWR VGND sg13g2_decap_8
XFILLER_33_330 VPWR VGND sg13g2_decap_4
XFILLER_33_352 VPWR VGND sg13g2_fill_1
XFILLER_34_864 VPWR VGND sg13g2_decap_8
XFILLER_21_547 VPWR VGND sg13g2_decap_8
Xu_ppwm_u_mem__1166__104 VPWR VGND net104 sg13g2_tiehi
XFILLER_14_1003 VPWR VGND sg13g2_decap_8
Xu_ppwm_u_ex__0937_ u_ppwm_u_ex__0936_/Y VPWR u_ppwm_u_ex__1073_/A VGND u_ppwm_u_ex__0874_/B
+ u_ppwm_u_ex__0934_/Y sg13g2_o21ai_1
Xu_ppwm_u_ex__0868_ VGND VPWR u_ppwm_u_ex__0888_/C net366 hold278/A sg13g2_or2_1
Xu_ppwm_u_ex__0799_ u_ppwm_u_ex__0575_/Y u_ppwm_u_ex__0658_/A u_ppwm_u_ex__0896_/B
+ u_ppwm_u_ex__0799_/X VPWR VGND sg13g2_mux2_1
Xhold37 hold37/A VPWR VGND net254 sg13g2_dlygate4sd3_1
Xhold15 hold15/A VPWR VGND net232 sg13g2_dlygate4sd3_1
Xhold26 hold26/A VPWR VGND net243 sg13g2_dlygate4sd3_1
Xhold59 hold59/A VPWR VGND net276 sg13g2_dlygate4sd3_1
Xhold48 hold48/A VPWR VGND net265 sg13g2_dlygate4sd3_1
XFILLER_29_647 VPWR VGND sg13g2_decap_8
XFILLER_28_157 VPWR VGND sg13g2_decap_4
XFILLER_44_628 VPWR VGND sg13g2_decap_8
XFILLER_16_319 VPWR VGND sg13g2_fill_1
XFILLER_45_58 VPWR VGND sg13g2_fill_1
XFILLER_25_886 VPWR VGND sg13g2_decap_8
XFILLER_40_856 VPWR VGND sg13g2_decap_8
XFILLER_8_507 VPWR VGND sg13g2_decap_8
XFILLER_12_569 VPWR VGND sg13g2_decap_8
XFILLER_20_580 VPWR VGND sg13g2_decap_8
XFILLER_4_746 VPWR VGND sg13g2_decap_8
XFILLER_48_912 VPWR VGND sg13g2_decap_8
XFILLER_0_952 VPWR VGND sg13g2_decap_8
XFILLER_47_422 VPWR VGND sg13g2_decap_8
XFILLER_48_989 VPWR VGND sg13g2_decap_8
Xu_ppwm_u_mem__1150_ net167 VGND VPWR net238 hold20/A clknet_5_24__leaf_clk sg13g2_dfrbpq_1
XFILLER_47_499 VPWR VGND sg13g2_decap_8
Xu_ppwm_u_mem__1081_ u_ppwm_u_mem__1081_/A u_ppwm_u_mem__1081_/B net519 u_ppwm_u_mem__1081_/D
+ hold137/A VPWR VGND sg13g2_nor4_1
XFILLER_35_639 VPWR VGND sg13g2_decap_8
XFILLER_16_842 VPWR VGND sg13g2_decap_8
XFILLER_43_694 VPWR VGND sg13g2_decap_8
XFILLER_15_374 VPWR VGND sg13g2_fill_1
XFILLER_30_322 VPWR VGND sg13g2_decap_4
XFILLER_31_845 VPWR VGND sg13g2_decap_8
Xu_ppwm_u_mem__0934_ VGND VPWR u_ppwm_u_mem__0665_/Y net419 u_ppwm_u_mem__1137_/D
+ u_ppwm_u_mem__0933_/Y sg13g2_a21oi_1
XFILLER_7_540 VPWR VGND sg13g2_decap_8
Xu_ppwm_u_ex__0722_ u_ppwm_u_ex__0727_/B hold271/A u_ppwm_u_ex__0722_/B VPWR VGND
+ sg13g2_nand2_1
XFILLER_11_591 VPWR VGND sg13g2_decap_8
Xu_ppwm_u_mem__0865_ net490 VPWR u_ppwm_u_mem__0865_/Y VGND hold166/A net396 sg13g2_o21ai_1
Xu_ppwm_u_ex__0653_ VPWR VGND u_ppwm_u_ex__0652_/X u_ppwm_u_ex__0995_/A u_ppwm_u_ex__0651_/Y
+ u_ppwm_u_ex__0648_/Y u_ppwm_u_ex__0655_/A u_ppwm_u_ex__0650_/Y sg13g2_a221oi_1
Xu_ppwm_u_mem__0796_ hold86/A hold74/A net474 u_ppwm_u_mem__0796_/X VPWR VGND sg13g2_mux2_1
Xu_ppwm_u_ex__0584_ VPWR u_ppwm_u_ex__0625_/A net512 VGND sg13g2_inv_1
XFILLER_39_934 VPWR VGND sg13g2_decap_8
Xu_ppwm_u_ex__1136_ net42 VGND VPWR u_ppwm_u_ex__1136_/D hold295/A clknet_5_17__leaf_clk
+ sg13g2_dfrbpq_1
Xu_ppwm_u_global_counter__125_ hold283/A net424 u_ppwm_u_global_counter__129_/A VPWR
+ VGND sg13g2_xnor2_1
XFILLER_26_606 VPWR VGND sg13g2_decap_8
Xu_ppwm_u_ex__1067_ u_ppwm_u_ex__1087_/A u_ppwm_u_ex__1067_/B u_ppwm_u_ex__1077_/B
+ VPWR VGND sg13g2_and2_1
XFILLER_34_661 VPWR VGND sg13g2_decap_8
XFILLER_22_812 VPWR VGND sg13g2_decap_8
XFILLER_22_889 VPWR VGND sg13g2_decap_8
XFILLER_1_727 VPWR VGND sg13g2_decap_8
XFILLER_0_248 VPWR VGND sg13g2_decap_4
XFILLER_13_812 VPWR VGND sg13g2_decap_8
XFILLER_25_683 VPWR VGND sg13g2_decap_8
XFILLER_40_653 VPWR VGND sg13g2_decap_8
XFILLER_8_326 VPWR VGND sg13g2_fill_2
XFILLER_8_304 VPWR VGND sg13g2_fill_2
XFILLER_12_388 VPWR VGND sg13g2_fill_1
XFILLER_13_889 VPWR VGND sg13g2_decap_8
XFILLER_4_543 VPWR VGND sg13g2_decap_8
Xu_ppwm_u_mem__0650_ VPWR u_ppwm_u_mem__0650_/Y net282 VGND sg13g2_inv_1
Xu_ppwm_u_mem__1202_ net141 VGND VPWR net313 hold94/A clknet_5_2__leaf_clk sg13g2_dfrbpq_2
XFILLER_48_786 VPWR VGND sg13g2_decap_8
Xu_ppwm_u_mem__1133_ net85 VGND VPWR net267 hold49/A clknet_5_31__leaf_clk sg13g2_dfrbpq_1
Xu_ppwm_u_mem__1064_ hold253/A u_ppwm_u_mem__1063_/X u_ppwm_u_mem__0833_/Y u_ppwm_u_mem__1060_/X
+ net635 VPWR VGND sg13g2_a22oi_1
XFILLER_23_609 VPWR VGND sg13g2_decap_8
Xheichips25_ppwm_9 VPWR VGND uio_oe[5] sg13g2_tielo
XFILLER_44_992 VPWR VGND sg13g2_decap_8
XFILLER_43_491 VPWR VGND sg13g2_decap_8
Xclkbuf_0_clk clk clknet_0_clk VPWR VGND sg13g2_buf_8
XFILLER_31_642 VPWR VGND sg13g2_decap_8
XFILLER_30_185 VPWR VGND sg13g2_fill_1
Xu_ppwm_u_mem__0917_ net505 VPWR u_ppwm_u_mem__0917_/Y VGND net317 net416 sg13g2_o21ai_1
XFILLER_8_871 VPWR VGND sg13g2_decap_8
Xu_ppwm_u_ex__0705_ VGND VPWR u_ppwm_u_ex__0700_/Y u_ppwm_u_ex__0704_/Y u_ppwm_u_ex__0776_/A
+ u_ppwm_u_ex__0678_/Y sg13g2_a21oi_1
Xhold304 hold304/A VPWR VGND net687 sg13g2_dlygate4sd3_1
Xu_ppwm_u_mem__0848_ VGND VPWR u_ppwm_u_mem__0708_/Y net393 hold116/A u_ppwm_u_mem__0847_/Y
+ sg13g2_a21oi_1
Xu_ppwm_u_ex__0636_ VGND VPWR u_ppwm_u_ex__0642_/B u_ppwm_u_ex__0635_/Y u_ppwm_u_ex__0639_/B
+ u_ppwm_u_ex__0630_/X sg13g2_a21oi_1
Xu_ppwm_u_mem__0779_ hold49/A hold34/A net472 u_ppwm_u_mem__0779_/X VPWR VGND sg13g2_mux2_1
XFILLER_39_731 VPWR VGND sg13g2_decap_8
XFILLER_38_230 VPWR VGND sg13g2_decap_8
XFILLER_27_904 VPWR VGND sg13g2_decap_8
Xu_ppwm_u_global_counter__108_ hold274/A net495 net656 u_ppwm_u_global_counter__120_/C
+ VPWR VGND sg13g2_and3_1
Xu_ppwm_u_ex__1119_ net37 VGND VPWR u_ppwm_u_ex__1119_/D hold258/A clknet_5_16__leaf_clk
+ sg13g2_dfrbpq_1
XFILLER_38_274 VPWR VGND sg13g2_fill_1
XFILLER_22_686 VPWR VGND sg13g2_decap_8
XFILLER_10_859 VPWR VGND sg13g2_decap_8
XFILLER_1_524 VPWR VGND sg13g2_decap_8
XFILLER_27_1002 VPWR VGND sg13g2_decap_8
Xu_ppwm_u_mem__1179__169 VPWR VGND net169 sg13g2_tiehi
XFILLER_17_403 VPWR VGND sg13g2_fill_2
XFILLER_45_767 VPWR VGND sg13g2_decap_8
XFILLER_33_907 VPWR VGND sg13g2_decap_8
XFILLER_26_970 VPWR VGND sg13g2_decap_8
XFILLER_41_951 VPWR VGND sg13g2_decap_8
XFILLER_25_480 VPWR VGND sg13g2_decap_8
XFILLER_13_686 VPWR VGND sg13g2_decap_8
XFILLER_8_145 VPWR VGND sg13g2_fill_2
XFILLER_9_668 VPWR VGND sg13g2_decap_8
Xu_ppwm_u_mem__0702_ VPWR u_ppwm_u_mem__0702_/Y net569 VGND sg13g2_inv_1
XFILLER_5_874 VPWR VGND sg13g2_decap_8
Xu_ppwm_u_mem__0633_ VPWR u_ppwm_u_mem__0633_/Y net541 VGND sg13g2_inv_1
XFILLER_48_583 VPWR VGND sg13g2_decap_8
Xu_ppwm_u_mem__1116_ net119 VGND VPWR net294 hold76/A clknet_5_26__leaf_clk sg13g2_dfrbpq_1
XFILLER_24_929 VPWR VGND sg13g2_decap_8
XFILLER_36_767 VPWR VGND sg13g2_decap_8
Xu_ppwm_u_mem__1047_ net498 VPWR u_ppwm_u_mem__1047_/Y VGND net247 net406 sg13g2_o21ai_1
XFILLER_32_984 VPWR VGND sg13g2_decap_8
Xhold101 hold101/A VPWR VGND net318 sg13g2_dlygate4sd3_1
Xhold112 hold112/A VPWR VGND net329 sg13g2_dlygate4sd3_1
Xhold123 hold123/A VPWR VGND net340 sg13g2_dlygate4sd3_1
Xhold134 hold134/A VPWR VGND net517 sg13g2_dlygate4sd3_1
Xhold167 hold167/A VPWR VGND net550 sg13g2_dlygate4sd3_1
Xhold156 hold156/A VPWR VGND net539 sg13g2_dlygate4sd3_1
Xu_ppwm_u_ex__0619_ net455 net458 net451 u_ppwm_u_ex__0652_/A VPWR VGND net467 sg13g2_nand4_1
Xhold145 hold145/A VPWR VGND net528 sg13g2_dlygate4sd3_1
Xhold189 hold189/A VPWR VGND net572 sg13g2_dlygate4sd3_1
Xhold178 hold178/A VPWR VGND net561 sg13g2_dlygate4sd3_1
XFILLER_27_701 VPWR VGND sg13g2_decap_8
XFILLER_2_1026 VPWR VGND sg13g2_fill_2
XFILLER_26_222 VPWR VGND sg13g2_fill_1
XFILLER_27_778 VPWR VGND sg13g2_decap_8
XFILLER_42_748 VPWR VGND sg13g2_decap_8
XFILLER_23_973 VPWR VGND sg13g2_decap_8
XFILLER_22_483 VPWR VGND sg13g2_decap_8
XFILLER_10_656 VPWR VGND sg13g2_decap_8
XFILLER_6_638 VPWR VGND sg13g2_decap_8
XFILLER_2_844 VPWR VGND sg13g2_decap_8
XFILLER_1_398 VPWR VGND sg13g2_decap_8
XFILLER_49_369 VPWR VGND sg13g2_decap_8
XFILLER_40_1010 VPWR VGND sg13g2_decap_8
XFILLER_45_564 VPWR VGND sg13g2_decap_8
XFILLER_18_767 VPWR VGND sg13g2_decap_8
XFILLER_33_704 VPWR VGND sg13g2_decap_8
XFILLER_27_92 VPWR VGND sg13g2_fill_1
XFILLER_32_203 VPWR VGND sg13g2_decap_4
Xu_ppwm_u_ex__0970_ u_ppwm_u_ex__0970_/Y net431 u_ppwm_u_ex__0970_/B VPWR VGND sg13g2_nand2_1
XFILLER_14_940 VPWR VGND sg13g2_decap_8
XFILLER_13_483 VPWR VGND sg13g2_decap_8
XFILLER_5_671 VPWR VGND sg13g2_decap_8
Xu_ppwm_u_mem__0616_ VPWR u_ppwm_u_mem__0616_/Y net517 VGND sg13g2_inv_1
Xheichips25_ppwm_19 VPWR VGND uio_out[7] sg13g2_tielo
XFILLER_48_380 VPWR VGND sg13g2_decap_8
XFILLER_24_726 VPWR VGND sg13g2_decap_8
XFILLER_36_564 VPWR VGND sg13g2_decap_8
XFILLER_23_39 VPWR VGND sg13g2_fill_2
XFILLER_32_781 VPWR VGND sg13g2_decap_8
XFILLER_20_965 VPWR VGND sg13g2_decap_8
XFILLER_2_118 VPWR VGND sg13g2_decap_8
Xfanout400 net402 net400 VPWR VGND sg13g2_buf_1
XFILLER_48_14 VPWR VGND sg13g2_decap_8
Xfanout411 net415 net411 VPWR VGND sg13g2_buf_8
Xfanout422 net649 net422 VPWR VGND sg13g2_buf_8
Xfanout444 net445 net444 VPWR VGND sg13g2_buf_8
Xfanout433 net685 net433 VPWR VGND sg13g2_buf_1
XFILLER_24_1027 VPWR VGND sg13g2_fill_2
Xfanout455 net456 net455 VPWR VGND sg13g2_buf_1
Xfanout466 net471 net466 VPWR VGND sg13g2_buf_8
XFILLER_47_807 VPWR VGND sg13g2_decap_8
Xfanout477 net493 net477 VPWR VGND sg13g2_buf_1
Xfanout499 net502 net499 VPWR VGND sg13g2_buf_1
Xfanout488 net491 net488 VPWR VGND sg13g2_buf_8
XFILLER_46_328 VPWR VGND sg13g2_fill_2
XFILLER_27_575 VPWR VGND sg13g2_decap_8
XFILLER_42_545 VPWR VGND sg13g2_decap_8
XFILLER_15_759 VPWR VGND sg13g2_decap_8
XFILLER_23_770 VPWR VGND sg13g2_decap_8
XFILLER_7_925 VPWR VGND sg13g2_decap_8
Xu_ppwm_u_pwm__140_ VPWR u_ppwm_u_pwm__160_/B net633 VGND sg13g2_inv_1
XFILLER_11_976 VPWR VGND sg13g2_decap_8
XFILLER_6_435 VPWR VGND sg13g2_decap_8
XFILLER_2_641 VPWR VGND sg13g2_decap_8
XFILLER_1_173 VPWR VGND sg13g2_decap_4
XFILLER_37_328 VPWR VGND sg13g2_fill_2
Xclkbuf_5_24__f_clk clknet_4_12_0_clk clknet_5_24__leaf_clk VPWR VGND sg13g2_buf_8
XFILLER_38_91 VPWR VGND sg13g2_decap_8
XFILLER_46_895 VPWR VGND sg13g2_decap_8
XFILLER_18_564 VPWR VGND sg13g2_decap_8
XFILLER_33_501 VPWR VGND sg13g2_decap_8
XFILLER_21_729 VPWR VGND sg13g2_decap_8
XFILLER_33_578 VPWR VGND sg13g2_decap_8
Xu_ppwm_u_ex__0953_ VGND VPWR net658 u_ppwm_u_ex__0785_/Y u_ppwm_u_ex__0954_/C u_ppwm_u_ex__0952_/Y
+ sg13g2_a21oi_1
Xu_ppwm_u_ex__0884_ u_ppwm_u_ex__0884_/A u_ppwm_u_ex__0882_/Y u_ppwm_u_ex__1125_/D
+ VPWR VGND sg13g2_nor2b_1
XFILLER_48_0 VPWR VGND sg13g2_decap_8
XFILLER_29_829 VPWR VGND sg13g2_decap_8
XFILLER_37_840 VPWR VGND sg13g2_decap_8
XFILLER_24_523 VPWR VGND sg13g2_decap_8
Xclkload4 VPWR clkload4/Y clknet_5_9__leaf_clk VGND sg13g2_inv_1
XFILLER_20_762 VPWR VGND sg13g2_decap_8
XFILLER_4_928 VPWR VGND sg13g2_decap_8
XFILLER_3_427 VPWR VGND sg13g2_decap_8
XFILLER_47_604 VPWR VGND sg13g2_decap_8
XFILLER_28_840 VPWR VGND sg13g2_decap_8
XFILLER_27_361 VPWR VGND sg13g2_fill_2
XFILLER_43_876 VPWR VGND sg13g2_decap_8
XFILLER_15_556 VPWR VGND sg13g2_decap_8
XFILLER_42_386 VPWR VGND sg13g2_fill_2
Xu_ppwm_u_mem__0950_ VGND VPWR u_ppwm_u_mem__0657_/Y net382 hold27/A u_ppwm_u_mem__0949_/Y
+ sg13g2_a21oi_1
Xu_ppwm_u_mem__0881_ net490 VPWR u_ppwm_u_mem__0881_/Y VGND net527 net400 sg13g2_o21ai_1
XFILLER_7_722 VPWR VGND sg13g2_decap_8
XFILLER_11_773 VPWR VGND sg13g2_decap_8
XFILLER_10_283 VPWR VGND sg13g2_decap_8
XFILLER_7_799 VPWR VGND sg13g2_decap_8
XFILLER_41_7 VPWR VGND sg13g2_fill_2
XFILLER_3_994 VPWR VGND sg13g2_decap_8
Xu_ppwm_u_global_counter__141_ u_ppwm_u_global_counter__141_/A u_ppwm_u_global_counter__141_/B
+ u_ppwm_u_global_counter__141_/C u_ppwm_u_global_counter__156_/C VGND VPWR u_ppwm_u_global_counter__141_/D
+ sg13g2_nor4_2
XFILLER_37_114 VPWR VGND sg13g2_fill_1
XFILLER_38_637 VPWR VGND sg13g2_decap_8
XFILLER_1_42 VPWR VGND sg13g2_fill_2
Xu_ppwm_u_ex__1083_ u_ppwm_u_ex__1084_/B u_ppwm_u_ex__1083_/A net341 VPWR VGND sg13g2_nand2_1
XFILLER_19_851 VPWR VGND sg13g2_decap_8
XFILLER_37_158 VPWR VGND sg13g2_fill_2
XFILLER_46_692 VPWR VGND sg13g2_decap_8
XFILLER_34_843 VPWR VGND sg13g2_decap_8
XFILLER_21_526 VPWR VGND sg13g2_decap_8
Xu_ppwm_u_ex__0936_ u_ppwm_u_ex__0936_/Y u_ppwm_u_ex__0935_/X u_ppwm_u_ex__0803_/A
+ u_ppwm_u_ex__0899_/Y u_ppwm_u_ex__0804_/Y VPWR VGND sg13g2_a22oi_1
Xu_ppwm_u_ex__0867_ VGND VPWR u_ppwm_u_ex__0854_/Y u_ppwm_u_ex__0888_/A u_ppwm_u_ex__0867_/Y
+ u_ppwm_u_ex__0855_/Y sg13g2_a21oi_1
Xu_ppwm_u_ex__0798_ u_ppwm_u_ex__0804_/C u_ppwm_u_ex__0797_/Y u_ppwm_u_ex__0803_/A
+ VPWR VGND sg13g2_nor2b_2
XFILLER_1_909 VPWR VGND sg13g2_decap_8
Xu_ppwm_u_mem__1103__144 VPWR VGND net144 sg13g2_tiehi
Xhold38 hold38/A VPWR VGND net255 sg13g2_dlygate4sd3_1
Xhold16 hold16/A VPWR VGND net233 sg13g2_dlygate4sd3_1
Xhold27 hold27/A VPWR VGND net244 sg13g2_dlygate4sd3_1
Xhold49 hold49/A VPWR VGND net266 sg13g2_dlygate4sd3_1
XFILLER_29_626 VPWR VGND sg13g2_decap_8
XFILLER_44_607 VPWR VGND sg13g2_decap_8
XFILLER_43_106 VPWR VGND sg13g2_fill_1
XFILLER_36_180 VPWR VGND sg13g2_decap_8
XFILLER_24_331 VPWR VGND sg13g2_decap_8
XFILLER_25_865 VPWR VGND sg13g2_decap_8
XFILLER_36_191 VPWR VGND sg13g2_fill_2
XFILLER_40_835 VPWR VGND sg13g2_decap_8
XFILLER_12_548 VPWR VGND sg13g2_decap_8
XFILLER_4_725 VPWR VGND sg13g2_decap_8
XFILLER_3_224 VPWR VGND sg13g2_fill_1
XFILLER_10_40 VPWR VGND sg13g2_fill_2
XFILLER_3_257 VPWR VGND sg13g2_fill_1
XFILLER_0_931 VPWR VGND sg13g2_decap_8
XFILLER_48_968 VPWR VGND sg13g2_decap_8
XFILLER_47_478 VPWR VGND sg13g2_decap_8
Xu_ppwm_u_mem__1080_ u_ppwm_u_mem__1080_/A net381 u_ppwm_u_mem__1080_/C u_ppwm_u_mem__1081_/D
+ VPWR VGND sg13g2_nor3_1
XFILLER_35_618 VPWR VGND sg13g2_decap_8
XFILLER_16_821 VPWR VGND sg13g2_decap_8
XFILLER_35_70 VPWR VGND sg13g2_fill_2
XFILLER_37_1015 VPWR VGND sg13g2_decap_8
XFILLER_43_673 VPWR VGND sg13g2_decap_8
XFILLER_16_898 VPWR VGND sg13g2_decap_8
XFILLER_31_824 VPWR VGND sg13g2_decap_8
Xu_ppwm_u_mem__0933_ net505 VPWR u_ppwm_u_mem__0933_/Y VGND net283 net419 sg13g2_o21ai_1
Xu_ppwm_u_ex__0721_ u_ppwm_u_ex__0721_/A hold254/A u_ppwm_u_ex__0724_/B VPWR VGND
+ sg13g2_nor2_1
XFILLER_30_389 VPWR VGND sg13g2_fill_1
XFILLER_11_570 VPWR VGND sg13g2_decap_8
Xu_ppwm_u_mem__0864_ VGND VPWR u_ppwm_u_mem__0700_/Y net397 hold133/A u_ppwm_u_mem__0863_/Y
+ sg13g2_a21oi_1
Xu_ppwm_u_ex__0652_ u_ppwm_u_ex__0652_/A u_ppwm_u_ex__0652_/B u_ppwm_u_ex__0652_/X
+ VPWR VGND sg13g2_and2_1
Xu_ppwm_u_mem__0795_ hold147/A hold16/A net472 u_ppwm_u_mem__0795_/X VPWR VGND sg13g2_mux2_1
XFILLER_7_596 VPWR VGND sg13g2_decap_8
Xu_ppwm_u_ex__0583_ VPWR u_ppwm_u_ex__0855_/A net446 VGND sg13g2_inv_1
XFILLER_3_791 VPWR VGND sg13g2_decap_8
XFILLER_39_913 VPWR VGND sg13g2_decap_8
XFILLER_38_401 VPWR VGND sg13g2_fill_1
Xu_ppwm_u_global_counter__124_ net429 net668 u_ppwm_u_global_counter__129_/A u_ppwm_u_global_counter__167_/D
+ VPWR VGND sg13g2_nor3_1
Xu_ppwm_u_ex__1135_ net47 VGND VPWR u_ppwm_u_ex__1135_/D hold244/A clknet_5_23__leaf_clk
+ sg13g2_dfrbpq_2
Xu_ppwm_u_ex__1066_ u_ppwm_u_ex__1090_/A VPWR u_ppwm_u_ex__1067_/B VGND u_ppwm_u_ex__1042_/B
+ u_ppwm_u_ex__1088_/A sg13g2_o21ai_1
XFILLER_15_18 VPWR VGND sg13g2_decap_8
XFILLER_34_640 VPWR VGND sg13g2_decap_8
XFILLER_21_323 VPWR VGND sg13g2_decap_8
XFILLER_22_868 VPWR VGND sg13g2_decap_8
XFILLER_21_389 VPWR VGND sg13g2_fill_1
Xu_ppwm_u_ex__0919_ u_ppwm_u_ex__0920_/B net355 hold266/A net357 net426 VPWR VGND
+ sg13g2_a22oi_1
XFILLER_1_706 VPWR VGND sg13g2_decap_8
XFILLER_0_238 VPWR VGND sg13g2_fill_1
XFILLER_29_401 VPWR VGND sg13g2_fill_2
XFILLER_17_629 VPWR VGND sg13g2_decap_8
XFILLER_45_949 VPWR VGND sg13g2_decap_8
XFILLER_16_128 VPWR VGND sg13g2_fill_1
XFILLER_25_662 VPWR VGND sg13g2_decap_8
XFILLER_12_301 VPWR VGND sg13g2_fill_1
XFILLER_40_632 VPWR VGND sg13g2_decap_8
XFILLER_13_868 VPWR VGND sg13g2_decap_8
XFILLER_21_890 VPWR VGND sg13g2_decap_8
XFILLER_4_522 VPWR VGND sg13g2_decap_8
XFILLER_4_599 VPWR VGND sg13g2_decap_8
Xu_ppwm_u_mem__1201_ net173 VGND VPWR u_ppwm_u_mem__1201_/D hold252/A clknet_5_1__leaf_clk
+ sg13g2_dfrbpq_2
XFILLER_48_765 VPWR VGND sg13g2_decap_8
XFILLER_47_264 VPWR VGND sg13g2_fill_1
Xu_ppwm_u_mem__1132_ net87 VGND VPWR u_ppwm_u_mem__1132_/D hold78/A clknet_5_31__leaf_clk
+ sg13g2_dfrbpq_1
XFILLER_29_990 VPWR VGND sg13g2_decap_8
XFILLER_36_949 VPWR VGND sg13g2_decap_8
Xu_ppwm_u_mem__1063_ net626 net635 u_ppwm_u_mem__1063_/X VPWR VGND sg13g2_xor2_1
XFILLER_44_971 VPWR VGND sg13g2_decap_8
XFILLER_43_470 VPWR VGND sg13g2_decap_8
XFILLER_16_695 VPWR VGND sg13g2_decap_8
XFILLER_15_172 VPWR VGND sg13g2_fill_2
XFILLER_31_621 VPWR VGND sg13g2_decap_8
XFILLER_8_850 VPWR VGND sg13g2_decap_8
XFILLER_31_698 VPWR VGND sg13g2_decap_8
Xu_ppwm_u_mem__0916_ VGND VPWR u_ppwm_u_mem__0674_/Y net415 hold151/A u_ppwm_u_mem__0915_/Y
+ sg13g2_a21oi_1
XFILLER_11_1018 VPWR VGND sg13g2_decap_8
Xu_ppwm_u_ex__0704_ VGND VPWR u_ppwm_u_ex__0699_/A u_ppwm_u_ex__0698_/A u_ppwm_u_ex__0704_/Y
+ u_ppwm_u_ex__0703_/Y sg13g2_a21oi_1
Xu_ppwm_u_mem__0847_ net485 VPWR u_ppwm_u_mem__0847_/Y VGND hold118/A net393 sg13g2_o21ai_1
XFILLER_7_96 VPWR VGND sg13g2_fill_2
Xhold305 hold305/A VPWR VGND net688 sg13g2_dlygate4sd3_1
Xu_ppwm_u_ex__0635_ u_ppwm_u_ex__0652_/B u_ppwm_u_ex__0635_/B u_ppwm_u_ex__0635_/Y
+ VPWR VGND sg13g2_nor2_1
Xu_ppwm_u_mem__0778_ hold181/A hold110/A net472 u_ppwm_u_mem__0778_/X VPWR VGND sg13g2_mux2_1
XFILLER_39_710 VPWR VGND sg13g2_decap_8
XFILLER_39_787 VPWR VGND sg13g2_decap_8
Xu_ppwm_u_global_counter__107_ net655 net599 hold231/A u_ppwm_u_global_counter__120_/C
+ VPWR VGND net428 sg13g2_nand4_1
Xu_ppwm_u_ex__1118_ net39 VGND VPWR u_ppwm_u_ex__1118_/D hold286/A clknet_5_19__leaf_clk
+ sg13g2_dfrbpq_2
Xu_ppwm_u_ex__1049_ net494 VPWR u_ppwm_u_ex__1050_/A VGND net435 net343 sg13g2_o21ai_1
XFILLER_26_459 VPWR VGND sg13g2_decap_8
XFILLER_35_982 VPWR VGND sg13g2_decap_8
XFILLER_22_665 VPWR VGND sg13g2_decap_8
XFILLER_10_838 VPWR VGND sg13g2_decap_8
XFILLER_21_197 VPWR VGND sg13g2_fill_1
XFILLER_5_308 VPWR VGND sg13g2_fill_2
Xu_ppwm_u_global_counter__162__62 VPWR VGND net62 sg13g2_tiehi
XFILLER_1_503 VPWR VGND sg13g2_decap_8
Xclkbuf_5_5__f_clk clknet_4_2_0_clk clknet_5_5__leaf_clk VPWR VGND sg13g2_buf_8
XFILLER_29_253 VPWR VGND sg13g2_decap_4
XFILLER_45_746 VPWR VGND sg13g2_decap_8
XFILLER_44_201 VPWR VGND sg13g2_fill_1
XFILLER_17_437 VPWR VGND sg13g2_fill_2
XFILLER_18_949 VPWR VGND sg13g2_decap_8
XFILLER_41_930 VPWR VGND sg13g2_decap_8
XFILLER_13_665 VPWR VGND sg13g2_decap_8
XFILLER_34_1018 VPWR VGND sg13g2_decap_8
XFILLER_9_647 VPWR VGND sg13g2_decap_8
Xu_ppwm_u_mem__0701_ VPWR u_ppwm_u_mem__0701_/Y net574 VGND sg13g2_inv_1
XFILLER_5_853 VPWR VGND sg13g2_decap_8
XFILLER_4_374 VPWR VGND sg13g2_fill_1
Xu_ppwm_u_mem__0632_ VPWR u_ppwm_u_mem__0632_/Y net268 VGND sg13g2_inv_1
XFILLER_48_562 VPWR VGND sg13g2_decap_8
XFILLER_36_746 VPWR VGND sg13g2_decap_8
XFILLER_24_908 VPWR VGND sg13g2_decap_8
Xu_ppwm_u_mem__1115_ net121 VGND VPWR u_ppwm_u_mem__1115_/D hold87/A clknet_5_24__leaf_clk
+ sg13g2_dfrbpq_1
XFILLER_17_993 VPWR VGND sg13g2_decap_8
Xu_ppwm_u_mem__1046_ VGND VPWR u_ppwm_u_mem__0609_/Y net407 hold25/A u_ppwm_u_mem__1045_/Y
+ sg13g2_a21oi_1
XFILLER_32_963 VPWR VGND sg13g2_decap_8
XFILLER_31_495 VPWR VGND sg13g2_decap_8
Xhold113 hold113/A VPWR VGND net330 sg13g2_dlygate4sd3_1
Xhold124 hold124/A VPWR VGND net507 sg13g2_dlygate4sd3_1
XFILLER_7_190 VPWR VGND sg13g2_fill_1
Xhold135 hold135/A VPWR VGND net518 sg13g2_dlygate4sd3_1
Xhold102 hold102/A VPWR VGND net319 sg13g2_dlygate4sd3_1
Xhold157 hold157/A VPWR VGND net540 sg13g2_dlygate4sd3_1
Xu_ppwm_u_ex__0618_ net458 net467 net455 u_ppwm_u_ex__0651_/B VPWR VGND sg13g2_nand3_1
Xhold168 hold168/A VPWR VGND net551 sg13g2_dlygate4sd3_1
Xhold146 hold146/A VPWR VGND net529 sg13g2_dlygate4sd3_1
Xhold179 hold179/A VPWR VGND net562 sg13g2_dlygate4sd3_1
XFILLER_2_1005 VPWR VGND sg13g2_decap_8
XFILLER_39_584 VPWR VGND sg13g2_decap_8
XFILLER_26_201 VPWR VGND sg13g2_decap_8
XFILLER_27_757 VPWR VGND sg13g2_decap_8
XFILLER_42_727 VPWR VGND sg13g2_decap_8
XFILLER_23_952 VPWR VGND sg13g2_decap_8
XFILLER_10_635 VPWR VGND sg13g2_decap_8
XFILLER_6_617 VPWR VGND sg13g2_decap_8
XFILLER_2_823 VPWR VGND sg13g2_decap_8
XFILLER_1_355 VPWR VGND sg13g2_decap_4
XFILLER_1_377 VPWR VGND sg13g2_decap_8
XFILLER_49_348 VPWR VGND sg13g2_decap_8
XFILLER_17_212 VPWR VGND sg13g2_decap_8
XFILLER_45_543 VPWR VGND sg13g2_decap_8
XFILLER_18_746 VPWR VGND sg13g2_decap_8
XFILLER_13_440 VPWR VGND sg13g2_fill_1
XFILLER_9_411 VPWR VGND sg13g2_decap_8
XFILLER_14_996 VPWR VGND sg13g2_decap_8
XFILLER_40_281 VPWR VGND sg13g2_fill_1
XFILLER_5_650 VPWR VGND sg13g2_decap_8
XFILLER_4_193 VPWR VGND sg13g2_decap_8
Xu_ppwm_u_mem__0615_ VPWR u_ppwm_u_mem__0615_/Y net284 VGND sg13g2_inv_1
XFILLER_36_543 VPWR VGND sg13g2_decap_8
XFILLER_24_705 VPWR VGND sg13g2_decap_8
XFILLER_17_790 VPWR VGND sg13g2_decap_8
XFILLER_23_215 VPWR VGND sg13g2_decap_4
XFILLER_23_18 VPWR VGND sg13g2_decap_8
XFILLER_23_259 VPWR VGND sg13g2_decap_4
XFILLER_32_760 VPWR VGND sg13g2_decap_8
Xu_ppwm_u_mem__1029_ net503 VPWR u_ppwm_u_mem__1029_/Y VGND hold134/A net410 sg13g2_o21ai_1
XFILLER_20_944 VPWR VGND sg13g2_decap_8
XFILLER_3_609 VPWR VGND sg13g2_decap_8
Xu_ppwm_u_mem__1145__180 VPWR VGND net180 sg13g2_tiehi
Xfanout401 net402 net401 VPWR VGND sg13g2_buf_8
Xfanout412 net415 net412 VPWR VGND sg13g2_buf_1
Xfanout423 net645 net423 VPWR VGND sg13g2_buf_8
Xfanout434 hold261/A net434 VPWR VGND sg13g2_buf_8
Xfanout445 net688 net445 VPWR VGND sg13g2_buf_8
XFILLER_24_1006 VPWR VGND sg13g2_decap_8
Xfanout456 net669 net456 VPWR VGND sg13g2_buf_8
Xfanout489 net491 net489 VPWR VGND sg13g2_buf_8
Xfanout478 net480 net478 VPWR VGND sg13g2_buf_8
Xfanout467 net470 net467 VPWR VGND sg13g2_buf_8
XFILLER_27_554 VPWR VGND sg13g2_decap_8
XFILLER_42_524 VPWR VGND sg13g2_decap_8
XFILLER_15_738 VPWR VGND sg13g2_decap_8
XFILLER_7_904 VPWR VGND sg13g2_decap_8
XFILLER_11_955 VPWR VGND sg13g2_decap_8
XFILLER_6_414 VPWR VGND sg13g2_decap_8
XFILLER_8_0 VPWR VGND sg13g2_fill_2
XFILLER_2_620 VPWR VGND sg13g2_decap_8
XFILLER_1_152 VPWR VGND sg13g2_decap_8
XFILLER_1_130 VPWR VGND sg13g2_decap_8
XFILLER_2_697 VPWR VGND sg13g2_decap_8
XFILLER_38_819 VPWR VGND sg13g2_decap_8
XFILLER_49_167 VPWR VGND sg13g2_fill_1
XFILLER_18_543 VPWR VGND sg13g2_decap_8
XFILLER_46_874 VPWR VGND sg13g2_decap_8
XFILLER_45_340 VPWR VGND sg13g2_fill_2
XFILLER_21_708 VPWR VGND sg13g2_decap_8
XFILLER_33_557 VPWR VGND sg13g2_decap_8
Xu_ppwm_u_ex__0952_ net351 u_ppwm_u_ex__0952_/B u_ppwm_u_ex__0952_/Y VPWR VGND sg13g2_nor2_1
XFILLER_14_793 VPWR VGND sg13g2_decap_8
XFILLER_20_207 VPWR VGND sg13g2_decap_4
Xu_ppwm_u_ex__0883_ net495 VPWR u_ppwm_u_ex__0884_/A VGND net661 net345 sg13g2_o21ai_1
Xu_ppwm_u_ex__1140__30 VPWR VGND net30 sg13g2_tiehi
XFILLER_6_981 VPWR VGND sg13g2_decap_8
XFILLER_47_1028 VPWR VGND sg13g2_fill_1
XFILLER_47_1017 VPWR VGND sg13g2_decap_8
Xu_ppwm_u_pwm__199_ VGND VPWR u_ppwm_u_pwm__128_/Y net380 hold193/A u_ppwm_u_pwm__198_/Y
+ sg13g2_a21oi_1
XFILLER_29_808 VPWR VGND sg13g2_decap_8
XFILLER_24_502 VPWR VGND sg13g2_decap_8
XFILLER_37_896 VPWR VGND sg13g2_decap_8
XFILLER_24_579 VPWR VGND sg13g2_decap_8
XFILLER_20_741 VPWR VGND sg13g2_decap_8
Xclkload5 clknet_5_12__leaf_clk clkload5/X VPWR VGND sg13g2_buf_1
XFILLER_4_907 VPWR VGND sg13g2_decap_8
XFILLER_3_406 VPWR VGND sg13g2_decap_8
Xclkbuf_5_30__f_clk clknet_4_15_0_clk clknet_5_30__leaf_clk VPWR VGND sg13g2_buf_8
Xu_ppwm_u_mem__1206__94 VPWR VGND net94 sg13g2_tiehi
XFILLER_1_7 VPWR VGND sg13g2_decap_8
XFILLER_8_1011 VPWR VGND sg13g2_decap_8
XFILLER_46_137 VPWR VGND sg13g2_fill_1
XFILLER_15_535 VPWR VGND sg13g2_decap_8
XFILLER_28_896 VPWR VGND sg13g2_decap_8
XFILLER_43_855 VPWR VGND sg13g2_decap_8
XFILLER_11_752 VPWR VGND sg13g2_decap_8
XFILLER_30_549 VPWR VGND sg13g2_decap_8
Xu_ppwm_u_mem__0880_ VGND VPWR u_ppwm_u_mem__0692_/Y net396 hold29/A u_ppwm_u_mem__0879_/Y
+ sg13g2_a21oi_1
XFILLER_10_251 VPWR VGND sg13g2_fill_1
XFILLER_7_701 VPWR VGND sg13g2_decap_8
XFILLER_7_778 VPWR VGND sg13g2_decap_8
XFILLER_40_82 VPWR VGND sg13g2_fill_2
XFILLER_3_973 VPWR VGND sg13g2_decap_8
XFILLER_34_7 VPWR VGND sg13g2_fill_2
Xu_ppwm_u_global_counter__140_ VGND VPWR hold246/A u_ppwm_u_global_counter__138_/B
+ hold223/A net605 sg13g2_a21oi_1
XFILLER_2_494 VPWR VGND sg13g2_decap_8
XFILLER_1_21 VPWR VGND sg13g2_decap_8
XFILLER_38_616 VPWR VGND sg13g2_decap_8
Xu_ppwm_u_ex__1082_ VGND VPWR u_ppwm_u_ex__1080_/Y u_ppwm_u_ex__1081_/Y u_ppwm_u_ex__1084_/A
+ net351 sg13g2_a21oi_1
XFILLER_19_830 VPWR VGND sg13g2_decap_8
XFILLER_46_671 VPWR VGND sg13g2_decap_8
XFILLER_34_822 VPWR VGND sg13g2_decap_8
XFILLER_21_505 VPWR VGND sg13g2_decap_8
XFILLER_34_899 VPWR VGND sg13g2_decap_8
XFILLER_14_590 VPWR VGND sg13g2_decap_8
Xu_ppwm_u_ex__0935_ net360 u_ppwm_u_ex__0935_/B u_ppwm_u_ex__0935_/X VPWR VGND sg13g2_and2_1
Xu_ppwm_u_ex__0866_ u_ppwm_u_ex__0888_/B hold278/A net366 VPWR VGND sg13g2_nand2_1
Xu_ppwm_u_ex__0797_ net372 u_ppwm_u_ex__0925_/B u_ppwm_u_ex__0797_/Y VPWR VGND sg13g2_nor2_1
Xhold17 hold17/A VPWR VGND net234 sg13g2_dlygate4sd3_1
Xhold28 hold28/A VPWR VGND net245 sg13g2_dlygate4sd3_1
XFILLER_29_39 VPWR VGND sg13g2_fill_1
XFILLER_21_1009 VPWR VGND sg13g2_decap_8
Xhold39 hold39/A VPWR VGND net256 sg13g2_dlygate4sd3_1
XFILLER_29_605 VPWR VGND sg13g2_decap_8
XFILLER_28_126 VPWR VGND sg13g2_fill_2
XFILLER_25_844 VPWR VGND sg13g2_decap_8
XFILLER_37_693 VPWR VGND sg13g2_decap_8
XFILLER_40_814 VPWR VGND sg13g2_decap_8
XFILLER_12_527 VPWR VGND sg13g2_decap_8
Xu_ppwm_u_global_counter__169__68 VPWR VGND net68 sg13g2_tiehi
XFILLER_4_704 VPWR VGND sg13g2_decap_8
XFILLER_3_247 VPWR VGND sg13g2_fill_2
XFILLER_0_910 VPWR VGND sg13g2_decap_8
XFILLER_0_987 VPWR VGND sg13g2_decap_8
XFILLER_48_947 VPWR VGND sg13g2_decap_8
XFILLER_47_457 VPWR VGND sg13g2_decap_8
XFILLER_16_800 VPWR VGND sg13g2_decap_8
XFILLER_28_693 VPWR VGND sg13g2_decap_8
XFILLER_43_652 VPWR VGND sg13g2_decap_8
XFILLER_16_877 VPWR VGND sg13g2_decap_8
XFILLER_31_803 VPWR VGND sg13g2_decap_8
XFILLER_42_151 VPWR VGND sg13g2_fill_1
Xu_ppwm_u_mem__0932_ VGND VPWR u_ppwm_u_mem__0666_/Y net416 u_ppwm_u_mem__1136_/D
+ u_ppwm_u_mem__0931_/Y sg13g2_a21oi_1
Xu_ppwm_u_ex__0720_ u_ppwm_u_ex__0719_/Y VPWR u_ppwm_u_ex__0727_/A VGND net441 u_ppwm_u_ex__0595_/Y
+ sg13g2_o21ai_1
Xu_ppwm_u_mem__0863_ net490 VPWR u_ppwm_u_mem__0863_/Y VGND hold142/A net396 sg13g2_o21ai_1
XFILLER_7_575 VPWR VGND sg13g2_decap_8
Xu_ppwm_u_ex__0651_ u_ppwm_u_ex__0651_/Y u_ppwm_u_ex__0651_/B net451 VPWR VGND sg13g2_nand2b_1
Xu_ppwm_u_mem__0794_ hold56/A hold161/A net472 u_ppwm_u_mem__0794_/X VPWR VGND sg13g2_mux2_1
Xu_ppwm_u_ex__0582_ hold278/A u_ppwm_u_ex__0658_/A VPWR VGND sg13g2_inv_4
XFILLER_3_770 VPWR VGND sg13g2_decap_8
XFILLER_2_291 VPWR VGND sg13g2_fill_2
XFILLER_39_969 VPWR VGND sg13g2_decap_8
Xu_ppwm_u_global_counter__123_ net425 u_ppwm_u_global_counter__132_/C u_ppwm_u_global_counter__129_/A
+ VPWR VGND sg13g2_and2_1
Xu_ppwm_u_ex__1134_ net51 VGND VPWR net687 hold303/A clknet_5_23__leaf_clk sg13g2_dfrbpq_1
Xu_ppwm_u_ex__1065_ VGND VPWR u_ppwm_u_ex__1088_/A u_ppwm_u_ex__1065_/B u_ppwm_u_ex__1065_/A
+ sg13g2_or2_1
XFILLER_34_696 VPWR VGND sg13g2_decap_8
XFILLER_22_847 VPWR VGND sg13g2_decap_8
Xu_ppwm_u_ex__0918_ VPWR VGND u_ppwm_u_ex__0803_/A u_ppwm_u_ex__0913_/Y u_ppwm_u_ex__0917_/Y
+ u_ppwm_u_ex__0804_/Y u_ppwm_u_ex__1058_/A u_ppwm_u_ex__0877_/X sg13g2_a221oi_1
Xu_ppwm_u_ex__0849_ u_ppwm_u_ex__0850_/C u_ppwm_u_ex__0848_/Y u_ppwm_u_ex__0827_/D
+ u_ppwm_u_ex__0872_/B u_ppwm_u_ex__0809_/Y VPWR VGND sg13g2_a22oi_1
Xu_ppwm_u_global_counter__174__71 VPWR VGND net71 sg13g2_tiehi
XFILLER_0_206 VPWR VGND sg13g2_decap_8
XFILLER_5_1014 VPWR VGND sg13g2_decap_8
XFILLER_45_928 VPWR VGND sg13g2_decap_8
XFILLER_17_608 VPWR VGND sg13g2_decap_8
XFILLER_29_468 VPWR VGND sg13g2_fill_2
XFILLER_29_479 VPWR VGND sg13g2_decap_8
XFILLER_38_980 VPWR VGND sg13g2_decap_8
XFILLER_25_641 VPWR VGND sg13g2_decap_8
XFILLER_37_490 VPWR VGND sg13g2_decap_8
XFILLER_40_611 VPWR VGND sg13g2_decap_8
XFILLER_13_847 VPWR VGND sg13g2_decap_8
XFILLER_40_688 VPWR VGND sg13g2_decap_8
XFILLER_8_306 VPWR VGND sg13g2_fill_1
XFILLER_9_829 VPWR VGND sg13g2_decap_8
XFILLER_4_501 VPWR VGND sg13g2_decap_8
XFILLER_4_578 VPWR VGND sg13g2_decap_8
XFILLER_48_744 VPWR VGND sg13g2_decap_8
XFILLER_0_784 VPWR VGND sg13g2_decap_8
Xu_ppwm_u_mem__1200_ net188 VGND VPWR u_ppwm_u_mem__1200_/D hold243/A clknet_5_3__leaf_clk
+ sg13g2_dfrbpq_2
Xu_ppwm_u_mem__1131_ net89 VGND VPWR u_ppwm_u_mem__1131_/D hold97/A clknet_5_31__leaf_clk
+ sg13g2_dfrbpq_1
XFILLER_36_928 VPWR VGND sg13g2_decap_8
XFILLER_44_950 VPWR VGND sg13g2_decap_8
Xu_ppwm_u_mem__1062_ VGND VPWR u_ppwm_u_mem__0602_/Y net381 u_ppwm_u_mem__1200_/D
+ u_ppwm_u_mem__1061_/Y sg13g2_a21oi_1
XFILLER_28_490 VPWR VGND sg13g2_decap_8
XFILLER_16_674 VPWR VGND sg13g2_decap_8
XFILLER_31_600 VPWR VGND sg13g2_decap_8
XFILLER_31_677 VPWR VGND sg13g2_decap_8
XFILLER_12_891 VPWR VGND sg13g2_decap_8
Xu_ppwm_u_mem__0915_ net500 VPWR u_ppwm_u_mem__0915_/Y VGND hold175/A net411 sg13g2_o21ai_1
Xu_ppwm_u_ex__0703_ VPWR u_ppwm_u_ex__0703_/Y net348 VGND sg13g2_inv_1
XFILLER_7_361 VPWR VGND sg13g2_fill_2
Xhold306 hold306/A VPWR VGND net689 sg13g2_dlygate4sd3_1
Xu_ppwm_u_ex__0634_ net377 u_ppwm_u_ex__0634_/C net467 u_ppwm_u_ex__0642_/B VPWR VGND
+ sg13g2_nand3_1
Xu_ppwm_u_mem__0846_ VGND VPWR u_ppwm_u_mem__0709_/Y net392 hold89/A u_ppwm_u_mem__0845_/Y
+ sg13g2_a21oi_1
Xu_ppwm_u_global_counter__171__63 VPWR VGND net63 sg13g2_tiehi
Xu_ppwm_u_mem__0777_ net452 VPWR u_ppwm_u_mem__0777_/Y VGND u_ppwm_u_mem__0773_/Y
+ u_ppwm_u_mem__0774_/Y sg13g2_o21ai_1
XFILLER_39_766 VPWR VGND sg13g2_decap_8
Xu_ppwm_u_global_counter__106_ hold273/A u_ppwm_u_global_counter__106_/B net655 VPWR
+ VGND sg13g2_nand2b_1
XFILLER_26_18 VPWR VGND sg13g2_decap_8
XFILLER_26_438 VPWR VGND sg13g2_decap_8
Xu_ppwm_u_ex__1117_ net41 VGND VPWR u_ppwm_u_ex__1117_/D fanout462/A clknet_5_19__leaf_clk
+ sg13g2_dfrbpq_1
XFILLER_27_939 VPWR VGND sg13g2_decap_8
XFILLER_42_909 VPWR VGND sg13g2_decap_8
Xu_ppwm_u_ex__1048_ net343 u_ppwm_u_ex__1048_/C u_ppwm_u_ex__1048_/A u_ppwm_u_ex__1048_/Y
+ VPWR VGND u_ppwm_u_ex__1048_/D sg13g2_nand4_1
XFILLER_35_961 VPWR VGND sg13g2_decap_8
XFILLER_22_644 VPWR VGND sg13g2_decap_8
XFILLER_34_493 VPWR VGND sg13g2_decap_8
XFILLER_10_817 VPWR VGND sg13g2_decap_8
XFILLER_1_559 VPWR VGND sg13g2_decap_8
XFILLER_45_725 VPWR VGND sg13g2_decap_8
XFILLER_18_928 VPWR VGND sg13g2_decap_8
XFILLER_32_408 VPWR VGND sg13g2_fill_2
XFILLER_13_644 VPWR VGND sg13g2_decap_8
XFILLER_41_986 VPWR VGND sg13g2_decap_8
XFILLER_9_626 VPWR VGND sg13g2_decap_8
XFILLER_12_143 VPWR VGND sg13g2_fill_1
XFILLER_40_485 VPWR VGND sg13g2_decap_8
XFILLER_8_169 VPWR VGND sg13g2_fill_1
Xu_ppwm_u_mem__1162__120 VPWR VGND net120 sg13g2_tiehi
XFILLER_5_832 VPWR VGND sg13g2_decap_8
Xu_ppwm_u_mem__0700_ VPWR u_ppwm_u_mem__0700_/Y net515 VGND sg13g2_inv_1
Xu_ppwm_u_mem__0631_ VPWR u_ppwm_u_mem__0631_/Y net510 VGND sg13g2_inv_1
XFILLER_0_581 VPWR VGND sg13g2_decap_8
XFILLER_48_541 VPWR VGND sg13g2_decap_8
XFILLER_36_725 VPWR VGND sg13g2_decap_8
Xu_ppwm_u_mem__1114_ net123 VGND VPWR u_ppwm_u_mem__1114_/D hold173/A clknet_5_15__leaf_clk
+ sg13g2_dfrbpq_1
XFILLER_17_972 VPWR VGND sg13g2_decap_8
Xu_ppwm_u_mem__1045_ net498 VPWR u_ppwm_u_mem__1045_/Y VGND hold119/A net407 sg13g2_o21ai_1
XFILLER_32_942 VPWR VGND sg13g2_decap_8
XFILLER_43_290 VPWR VGND sg13g2_fill_1
Xhold125 hold125/A VPWR VGND net508 sg13g2_dlygate4sd3_1
Xhold103 hold103/A VPWR VGND net320 sg13g2_dlygate4sd3_1
Xhold114 hold114/A VPWR VGND net331 sg13g2_dlygate4sd3_1
Xhold147 hold147/A VPWR VGND net530 sg13g2_dlygate4sd3_1
Xu_ppwm_u_mem__0829_ hold115/A hold191/A net464 u_ppwm_u_mem__0829_/X VPWR VGND sg13g2_mux2_1
Xhold136 hold136/A VPWR VGND net519 sg13g2_dlygate4sd3_1
Xu_ppwm_u_ex__0617_ u_ppwm_u_ex__0617_/Y net458 net467 VPWR VGND sg13g2_nand2_1
Xhold158 hold158/A VPWR VGND net541 sg13g2_dlygate4sd3_1
Xhold169 hold169/A VPWR VGND net552 sg13g2_dlygate4sd3_1
XFILLER_37_28 VPWR VGND sg13g2_decap_8
XFILLER_39_563 VPWR VGND sg13g2_decap_8
XFILLER_2_1028 VPWR VGND sg13g2_fill_1
XFILLER_27_736 VPWR VGND sg13g2_decap_8
XFILLER_42_706 VPWR VGND sg13g2_decap_8
XFILLER_23_931 VPWR VGND sg13g2_decap_8
XFILLER_10_614 VPWR VGND sg13g2_decap_8
XFILLER_2_802 VPWR VGND sg13g2_decap_8
XFILLER_2_879 VPWR VGND sg13g2_decap_8
XFILLER_18_725 VPWR VGND sg13g2_decap_8
XFILLER_45_522 VPWR VGND sg13g2_decap_8
XFILLER_17_235 VPWR VGND sg13g2_decap_4
Xu_ppwm_u_mem__1172__80 VPWR VGND net80 sg13g2_tiehi
XFILLER_17_257 VPWR VGND sg13g2_decap_4
XFILLER_45_599 VPWR VGND sg13g2_decap_8
XFILLER_33_739 VPWR VGND sg13g2_decap_8
XFILLER_14_975 VPWR VGND sg13g2_decap_8
XFILLER_41_783 VPWR VGND sg13g2_decap_8
Xu_ppwm_u_mem__0614_ VPWR u_ppwm_u_mem__0614_/Y net536 VGND sg13g2_inv_1
XFILLER_4_172 VPWR VGND sg13g2_decap_8
XFILLER_49_894 VPWR VGND sg13g2_decap_8
XFILLER_36_522 VPWR VGND sg13g2_decap_8
XFILLER_23_238 VPWR VGND sg13g2_fill_1
XFILLER_36_599 VPWR VGND sg13g2_decap_8
XFILLER_17_1014 VPWR VGND sg13g2_decap_8
Xu_ppwm_u_mem__1028_ VGND VPWR u_ppwm_u_mem__0618_/Y net416 u_ppwm_u_mem__1184_/D
+ u_ppwm_u_mem__1027_/Y sg13g2_a21oi_1
XFILLER_20_923 VPWR VGND sg13g2_decap_8
XFILLER_9_990 VPWR VGND sg13g2_decap_8
Xfanout413 net414 net413 VPWR VGND sg13g2_buf_8
Xfanout402 net403 net402 VPWR VGND sg13g2_buf_8
Xfanout446 net447 net446 VPWR VGND sg13g2_buf_8
Xfanout435 net678 net435 VPWR VGND sg13g2_buf_8
Xfanout424 net665 net424 VPWR VGND sg13g2_buf_8
Xfanout457 net462 net457 VPWR VGND sg13g2_buf_8
Xfanout479 net480 net479 VPWR VGND sg13g2_buf_1
Xfanout468 net470 net468 VPWR VGND sg13g2_buf_1
XFILLER_27_533 VPWR VGND sg13g2_decap_8
Xu_ppwm_u_mem__1113__125 VPWR VGND net125 sg13g2_tiehi
XFILLER_42_503 VPWR VGND sg13g2_decap_8
XFILLER_15_717 VPWR VGND sg13g2_decap_8
XFILLER_11_934 VPWR VGND sg13g2_decap_8
XFILLER_22_271 VPWR VGND sg13g2_fill_2
XFILLER_10_488 VPWR VGND sg13g2_decap_8
XFILLER_2_676 VPWR VGND sg13g2_decap_8
XFILLER_46_853 VPWR VGND sg13g2_decap_8
XFILLER_18_522 VPWR VGND sg13g2_decap_8
XFILLER_45_396 VPWR VGND sg13g2_fill_2
XFILLER_18_599 VPWR VGND sg13g2_decap_8
XFILLER_33_536 VPWR VGND sg13g2_decap_8
Xu_ppwm_u_ex__0951_ u_ppwm_u_ex__0952_/B net355 hold254/A net357 net425 VPWR VGND
+ sg13g2_a22oi_1
XFILLER_14_772 VPWR VGND sg13g2_decap_8
XFILLER_41_580 VPWR VGND sg13g2_decap_8
Xu_ppwm_u_ex__0882_ u_ppwm_u_ex__0882_/B u_ppwm_u_ex__1033_/A net345 u_ppwm_u_ex__0882_/Y
+ VPWR VGND u_ppwm_u_ex__0882_/D sg13g2_nand4_1
XFILLER_6_960 VPWR VGND sg13g2_decap_8
Xu_ppwm_u_pwm__198_ net481 VPWR u_ppwm_u_pwm__198_/Y VGND hold271/A net380 sg13g2_o21ai_1
XFILLER_49_691 VPWR VGND sg13g2_decap_8
XFILLER_48_190 VPWR VGND sg13g2_fill_2
XFILLER_37_875 VPWR VGND sg13g2_decap_8
XFILLER_12_709 VPWR VGND sg13g2_decap_8
XFILLER_24_558 VPWR VGND sg13g2_decap_8
XFILLER_11_208 VPWR VGND sg13g2_decap_4
XFILLER_20_720 VPWR VGND sg13g2_decap_8
Xclkload6 VPWR clkload6/Y clknet_5_17__leaf_clk VGND sg13g2_inv_1
Xu_ppwm_u_mem__1182__145 VPWR VGND net145 sg13g2_tiehi
XFILLER_20_797 VPWR VGND sg13g2_decap_8
XFILLER_30_1011 VPWR VGND sg13g2_decap_8
XFILLER_47_639 VPWR VGND sg13g2_decap_8
XFILLER_46_105 VPWR VGND sg13g2_decap_4
XFILLER_28_875 VPWR VGND sg13g2_decap_8
XFILLER_43_834 VPWR VGND sg13g2_decap_8
XFILLER_15_514 VPWR VGND sg13g2_decap_8
XFILLER_27_363 VPWR VGND sg13g2_fill_1
XFILLER_30_528 VPWR VGND sg13g2_decap_8
XFILLER_11_731 VPWR VGND sg13g2_decap_8
XFILLER_10_274 VPWR VGND sg13g2_decap_4
XFILLER_7_757 VPWR VGND sg13g2_decap_8
Xu_ppwm_u_ex__1122__31 VPWR VGND net31 sg13g2_tiehi
XFILLER_40_72 VPWR VGND sg13g2_fill_1
XFILLER_3_952 VPWR VGND sg13g2_decap_8
XFILLER_2_473 VPWR VGND sg13g2_decap_8
XFILLER_27_7 VPWR VGND sg13g2_decap_8
XFILLER_37_105 VPWR VGND sg13g2_fill_1
XFILLER_1_44 VPWR VGND sg13g2_fill_1
Xu_ppwm_u_ex__1081_ u_ppwm_u_ex__1081_/Y net347 net637 net359 hold276/A VPWR VGND
+ sg13g2_a22oi_1
XFILLER_46_650 VPWR VGND sg13g2_decap_8
XFILLER_34_801 VPWR VGND sg13g2_decap_8
XFILLER_18_374 VPWR VGND sg13g2_decap_4
XFILLER_19_886 VPWR VGND sg13g2_decap_8
XFILLER_45_193 VPWR VGND sg13g2_fill_1
XFILLER_33_322 VPWR VGND sg13g2_fill_2
XFILLER_34_878 VPWR VGND sg13g2_decap_8
XFILLER_33_366 VPWR VGND sg13g2_fill_1
Xu_ppwm_u_ex__0934_ VPWR VGND u_ppwm_u_ex__0803_/B u_ppwm_u_ex__0933_/X u_ppwm_u_ex__0966_/A
+ u_ppwm_u_ex__0846_/A u_ppwm_u_ex__0934_/Y u_ppwm_u_ex__0822_/X sg13g2_a221oi_1
XFILLER_14_1017 VPWR VGND sg13g2_decap_8
XFILLER_14_1028 VPWR VGND sg13g2_fill_1
Xu_ppwm_u_ex__0865_ u_ppwm_u_ex__0865_/A u_ppwm_u_ex__0863_/Y u_ppwm_u_ex__1124_/D
+ VPWR VGND sg13g2_nor2b_1
Xu_ppwm_u_ex__0796_ u_ppwm_u_ex__0804_/C u_ppwm/instr\[0\] u_ppwm_u_ex__0845_/C VPWR
+ VGND sg13g2_nand2_2
Xhold29 hold29/A VPWR VGND net246 sg13g2_dlygate4sd3_1
Xhold18 hold18/A VPWR VGND net235 sg13g2_dlygate4sd3_1
XFILLER_25_823 VPWR VGND sg13g2_decap_8
XFILLER_37_672 VPWR VGND sg13g2_decap_8
XFILLER_12_506 VPWR VGND sg13g2_decap_8
XFILLER_24_355 VPWR VGND sg13g2_fill_1
XFILLER_20_594 VPWR VGND sg13g2_decap_8
XFILLER_10_86 VPWR VGND sg13g2_fill_1
XFILLER_0_966 VPWR VGND sg13g2_decap_8
XFILLER_48_926 VPWR VGND sg13g2_decap_8
XFILLER_47_436 VPWR VGND sg13g2_decap_8
XFILLER_28_672 VPWR VGND sg13g2_decap_8
XFILLER_43_631 VPWR VGND sg13g2_decap_8
XFILLER_16_856 VPWR VGND sg13g2_decap_8
XFILLER_35_72 VPWR VGND sg13g2_fill_1
XFILLER_42_196 VPWR VGND sg13g2_decap_8
XFILLER_15_388 VPWR VGND sg13g2_fill_2
XFILLER_31_859 VPWR VGND sg13g2_decap_8
Xu_ppwm_u_mem__0931_ net506 VPWR u_ppwm_u_mem__0931_/Y VGND net300 net416 sg13g2_o21ai_1
XFILLER_7_554 VPWR VGND sg13g2_decap_8
Xu_ppwm_u_ex__0650_ u_ppwm_u_ex__0652_/B u_ppwm_u_ex__0650_/B u_ppwm_u_ex__0650_/Y
+ VPWR VGND sg13g2_nor2_1
Xu_ppwm_u_mem__0862_ VGND VPWR u_ppwm_u_mem__0701_/Y net393 u_ppwm_u_mem__1101_/D
+ u_ppwm_u_mem__0861_/Y sg13g2_a21oi_1
Xu_ppwm_u_ex__0581_ VPWR u_ppwm_u_ex__0689_/B net444 VGND sg13g2_inv_1
Xu_ppwm_u_mem__0793_ net452 VPWR u_ppwm_u_mem__0793_/Y VGND u_ppwm_u_mem__0789_/Y
+ u_ppwm_u_mem__0790_/Y sg13g2_o21ai_1
XFILLER_25_4 VPWR VGND sg13g2_fill_2
XFILLER_39_948 VPWR VGND sg13g2_decap_8
Xu_ppwm_u_global_counter__122_ net425 u_ppwm_u_global_counter__132_/C hold285/A VPWR
+ VGND sg13g2_nor2_1
Xu_ppwm_u_ex__1133_ net55 VGND VPWR net683 hold299/A clknet_5_23__leaf_clk sg13g2_dfrbpq_2
XFILLER_20_1021 VPWR VGND sg13g2_decap_8
Xu_ppwm_u_ex__1064_ fanout367/A VPWR u_ppwm_u_ex__1090_/A VGND net434 net435 sg13g2_o21ai_1
XFILLER_38_458 VPWR VGND sg13g2_fill_2
XFILLER_38_469 VPWR VGND sg13g2_decap_8
XFILLER_19_683 VPWR VGND sg13g2_decap_8
XFILLER_22_826 VPWR VGND sg13g2_decap_8
XFILLER_34_675 VPWR VGND sg13g2_decap_8
Xu_ppwm_u_ex__0917_ VGND VPWR net360 u_ppwm_u_ex__0897_/Y u_ppwm_u_ex__0917_/Y u_ppwm_u_ex__0916_/Y
+ sg13g2_a21oi_1
XFILLER_21_347 VPWR VGND sg13g2_decap_8
XFILLER_30_892 VPWR VGND sg13g2_decap_8
Xu_ppwm_u_ex__0848_ net365 net361 u_ppwm_u_ex__0848_/Y VPWR VGND sg13g2_nor2_1
Xu_ppwm_u_ex__0779_ u_ppwm_u_ex__0779_/Y u_ppwm_u_ex__0779_/B net359 VPWR VGND sg13g2_nand2b_1
XFILLER_45_907 VPWR VGND sg13g2_decap_8
XFILLER_16_108 VPWR VGND sg13g2_decap_8
XFILLER_25_620 VPWR VGND sg13g2_decap_8
XFILLER_13_826 VPWR VGND sg13g2_decap_8
XFILLER_9_808 VPWR VGND sg13g2_decap_8
XFILLER_25_697 VPWR VGND sg13g2_decap_8
XFILLER_40_667 VPWR VGND sg13g2_decap_8
XFILLER_4_557 VPWR VGND sg13g2_decap_8
XFILLER_0_763 VPWR VGND sg13g2_decap_8
XFILLER_48_723 VPWR VGND sg13g2_decap_8
XFILLER_47_211 VPWR VGND sg13g2_fill_1
XFILLER_47_255 VPWR VGND sg13g2_decap_8
Xu_ppwm_u_mem__1130_ net91 VGND VPWR u_ppwm_u_mem__1130_/D hold100/A clknet_5_31__leaf_clk
+ sg13g2_dfrbpq_1
XFILLER_36_907 VPWR VGND sg13g2_decap_8
Xu_ppwm_u_mem__1061_ net476 VPWR u_ppwm_u_mem__1061_/Y VGND u_ppwm_u_mem__0602_/Y
+ u_ppwm_u_mem__1060_/X sg13g2_o21ai_1
XFILLER_35_439 VPWR VGND sg13g2_decap_4
XFILLER_15_152 VPWR VGND sg13g2_fill_2
XFILLER_16_653 VPWR VGND sg13g2_decap_8
XFILLER_30_155 VPWR VGND sg13g2_decap_8
XFILLER_31_656 VPWR VGND sg13g2_decap_8
XFILLER_12_870 VPWR VGND sg13g2_decap_8
Xu_ppwm_u_mem__0914_ VGND VPWR u_ppwm_u_mem__0675_/Y net413 u_ppwm_u_mem__1127_/D
+ u_ppwm_u_mem__0913_/Y sg13g2_a21oi_1
Xu_ppwm_u_ex__0702_ net375 net359 fanout348/A VPWR VGND sg13g2_nor2_2
XFILLER_8_885 VPWR VGND sg13g2_decap_8
Xu_ppwm_u_ex__0633_ VGND VPWR net467 net377 u_ppwm_u_ex__0635_/B u_ppwm_u_ex__0634_/C
+ sg13g2_a21oi_1
Xu_ppwm_u_mem__0845_ net485 VPWR u_ppwm_u_mem__0845_/Y VGND hold115/A net392 sg13g2_o21ai_1
Xu_ppwm_u_mem__0776_ net453 u_ppwm_u_mem__0776_/B u_ppwm_u_mem__0776_/Y VPWR VGND
+ sg13g2_nor2_1
XFILLER_39_745 VPWR VGND sg13g2_decap_8
Xu_ppwm_u_global_counter__105_ net600 u_ppwm_u_global_counter__105_/B hold218/A VPWR
+ VGND sg13g2_nor2_1
XFILLER_27_918 VPWR VGND sg13g2_decap_8
Xu_ppwm_u_ex__1116_ net43 VGND VPWR u_ppwm_u_ex__1116_/D fanout474/A clknet_5_19__leaf_clk
+ sg13g2_dfrbpq_1
XFILLER_26_417 VPWR VGND sg13g2_decap_8
Xu_ppwm_u_ex__1047_ u_ppwm_u_ex__1046_/Y u_ppwm_u_ex__1045_/Y net353 u_ppwm_u_ex__1048_/D
+ VPWR VGND sg13g2_a21o_1
XFILLER_35_940 VPWR VGND sg13g2_decap_8
XFILLER_22_623 VPWR VGND sg13g2_decap_8
XFILLER_21_177 VPWR VGND sg13g2_fill_1
XFILLER_1_538 VPWR VGND sg13g2_decap_8
XFILLER_27_1016 VPWR VGND sg13g2_decap_8
XFILLER_27_1027 VPWR VGND sg13g2_fill_2
XFILLER_49_509 VPWR VGND sg13g2_decap_8
XFILLER_45_704 VPWR VGND sg13g2_decap_8
XFILLER_18_907 VPWR VGND sg13g2_decap_8
XFILLER_29_288 VPWR VGND sg13g2_decap_4
XFILLER_44_236 VPWR VGND sg13g2_fill_2
XFILLER_44_225 VPWR VGND sg13g2_fill_1
XFILLER_17_439 VPWR VGND sg13g2_fill_1
XFILLER_26_984 VPWR VGND sg13g2_decap_8
XFILLER_40_420 VPWR VGND sg13g2_fill_1
XFILLER_12_111 VPWR VGND sg13g2_decap_4
XFILLER_13_623 VPWR VGND sg13g2_decap_8
XFILLER_25_494 VPWR VGND sg13g2_decap_8
XFILLER_41_965 VPWR VGND sg13g2_decap_8
XFILLER_9_605 VPWR VGND sg13g2_decap_8
XFILLER_40_464 VPWR VGND sg13g2_decap_8
Xu_ppwm_u_mem__1123__105 VPWR VGND net105 sg13g2_tiehi
XFILLER_5_811 VPWR VGND sg13g2_decap_8
XFILLER_10_1020 VPWR VGND sg13g2_decap_8
Xu_ppwm_u_mem__0630_ VPWR u_ppwm_u_mem__0630_/Y net592 VGND sg13g2_inv_1
XFILLER_5_888 VPWR VGND sg13g2_decap_8
XFILLER_48_520 VPWR VGND sg13g2_decap_8
XFILLER_0_560 VPWR VGND sg13g2_decap_8
XFILLER_48_597 VPWR VGND sg13g2_decap_8
XFILLER_36_704 VPWR VGND sg13g2_decap_8
Xu_ppwm_u_mem__1113_ net125 VGND VPWR net292 hold74/A clknet_5_14__leaf_clk sg13g2_dfrbpq_1
Xu_ppwm_u_pwm__238__201 VPWR VGND net201 sg13g2_tiehi
XFILLER_17_951 VPWR VGND sg13g2_decap_8
XFILLER_23_409 VPWR VGND sg13g2_fill_1
Xu_ppwm_u_mem__1044_ VGND VPWR u_ppwm_u_mem__0610_/Y net407 u_ppwm_u_mem__1192_/D
+ u_ppwm_u_mem__1043_/Y sg13g2_a21oi_1
XFILLER_16_461 VPWR VGND sg13g2_fill_2
XFILLER_32_921 VPWR VGND sg13g2_decap_8
XFILLER_32_998 VPWR VGND sg13g2_decap_8
XFILLER_8_682 VPWR VGND sg13g2_decap_8
Xhold115 hold115/A VPWR VGND net332 sg13g2_dlygate4sd3_1
Xhold126 hold126/A VPWR VGND net509 sg13g2_dlygate4sd3_1
Xhold104 hold104/A VPWR VGND net321 sg13g2_dlygate4sd3_1
Xu_ppwm_u_mem__0828_ hold124/A hold87/A net463 u_ppwm_u_mem__0828_/X VPWR VGND sg13g2_mux2_1
Xhold137 hold137/A VPWR VGND net520 sg13g2_dlygate4sd3_1
Xhold159 hold159/A VPWR VGND net542 sg13g2_dlygate4sd3_1
Xu_ppwm_u_ex__0616_ net614 VPWR u_ppwm_u_ex__0616_/Y VGND net590 net602 sg13g2_o21ai_1
Xhold148 hold148/A VPWR VGND net531 sg13g2_dlygate4sd3_1
Xu_ppwm_u_mem__0759_ net465 hold174/A hold14/A hold109/A hold106/A net457 u_ppwm_u_mem__0760_/B
+ VPWR VGND sg13g2_mux4_1
XFILLER_39_542 VPWR VGND sg13g2_decap_8
XFILLER_27_715 VPWR VGND sg13g2_decap_8
XFILLER_26_236 VPWR VGND sg13g2_decap_4
XFILLER_41_217 VPWR VGND sg13g2_decap_8
XFILLER_23_910 VPWR VGND sg13g2_decap_8
XFILLER_22_442 VPWR VGND sg13g2_fill_2
XFILLER_22_453 VPWR VGND sg13g2_fill_2
XFILLER_23_987 VPWR VGND sg13g2_decap_8
XFILLER_22_497 VPWR VGND sg13g2_decap_8
Xclkbuf_5_13__f_clk clknet_4_6_0_clk clknet_5_13__leaf_clk VPWR VGND sg13g2_buf_8
XFILLER_2_858 VPWR VGND sg13g2_decap_8
XFILLER_45_501 VPWR VGND sg13g2_decap_8
XFILLER_40_1024 VPWR VGND sg13g2_decap_4
XFILLER_18_704 VPWR VGND sg13g2_decap_8
XFILLER_45_578 VPWR VGND sg13g2_decap_8
XFILLER_27_84 VPWR VGND sg13g2_fill_1
XFILLER_33_718 VPWR VGND sg13g2_decap_8
XFILLER_26_781 VPWR VGND sg13g2_decap_8
XFILLER_14_954 VPWR VGND sg13g2_decap_8
XFILLER_43_72 VPWR VGND sg13g2_fill_2
XFILLER_41_762 VPWR VGND sg13g2_decap_8
XFILLER_13_497 VPWR VGND sg13g2_decap_8
XFILLER_9_479 VPWR VGND sg13g2_decap_8
XFILLER_5_685 VPWR VGND sg13g2_decap_8
Xu_ppwm_u_mem__0613_ VPWR u_ppwm_u_mem__0613_/Y net546 VGND sg13g2_inv_1
XFILLER_49_873 VPWR VGND sg13g2_decap_8
XFILLER_36_501 VPWR VGND sg13g2_decap_8
XFILLER_48_394 VPWR VGND sg13g2_decap_8
XFILLER_36_578 VPWR VGND sg13g2_decap_8
Xu_ppwm_u_mem__1027_ net503 VPWR u_ppwm_u_mem__1027_/Y VGND net258 net416 sg13g2_o21ai_1
XFILLER_20_902 VPWR VGND sg13g2_decap_8
XFILLER_31_272 VPWR VGND sg13g2_fill_1
XFILLER_32_795 VPWR VGND sg13g2_decap_8
XFILLER_20_979 VPWR VGND sg13g2_decap_8
Xfanout414 net415 net414 VPWR VGND sg13g2_buf_8
Xfanout403 net404 net403 VPWR VGND sg13g2_buf_8
XFILLER_48_28 VPWR VGND sg13g2_decap_8
Xfanout436 hold295/A net436 VPWR VGND sg13g2_buf_1
Xfanout425 net667 net425 VPWR VGND sg13g2_buf_8
Xfanout447 net670 net447 VPWR VGND sg13g2_buf_8
Xfanout458 net459 net458 VPWR VGND sg13g2_buf_8
Xfanout469 net470 net469 VPWR VGND sg13g2_buf_2
XFILLER_46_309 VPWR VGND sg13g2_fill_1
XFILLER_27_512 VPWR VGND sg13g2_decap_8
XFILLER_27_589 VPWR VGND sg13g2_decap_8
XFILLER_42_559 VPWR VGND sg13g2_decap_8
XFILLER_11_913 VPWR VGND sg13g2_decap_8
XFILLER_23_784 VPWR VGND sg13g2_decap_8
XFILLER_13_31 VPWR VGND sg13g2_decap_4
Xu_ppwm_u_ex__1134__51 VPWR VGND net51 sg13g2_tiehi
XFILLER_7_939 VPWR VGND sg13g2_decap_8
XFILLER_13_64 VPWR VGND sg13g2_fill_1
XFILLER_6_449 VPWR VGND sg13g2_decap_8
XFILLER_8_2 VPWR VGND sg13g2_fill_1
XFILLER_2_655 VPWR VGND sg13g2_decap_8
XFILLER_49_103 VPWR VGND sg13g2_decap_8
XFILLER_49_147 VPWR VGND sg13g2_decap_8
XFILLER_18_501 VPWR VGND sg13g2_decap_8
XFILLER_46_832 VPWR VGND sg13g2_decap_8
XFILLER_18_578 VPWR VGND sg13g2_decap_8
XFILLER_33_515 VPWR VGND sg13g2_decap_8
XFILLER_14_751 VPWR VGND sg13g2_decap_8
Xu_ppwm_u_ex__0950_ u_ppwm_u_ex__1083_/A u_ppwm_u_ex__0949_/Y u_ppwm_u_ex__0983_/A
+ u_ppwm_u_ex__0917_/Y u_ppwm_u_ex__0804_/Y VPWR VGND sg13g2_a22oi_1
XFILLER_9_243 VPWR VGND sg13g2_decap_8
Xu_ppwm_u_ex__0881_ VGND VPWR net437 u_ppwm_u_ex__0785_/Y u_ppwm_u_ex__0882_/D u_ppwm_u_ex__0880_/Y
+ sg13g2_a21oi_1
XFILLER_9_254 VPWR VGND sg13g2_fill_1
Xu_ppwm_u_pwm__197_ VGND VPWR u_ppwm_u_pwm__200_/A net380 hold204/A u_ppwm_u_pwm__196_/Y
+ sg13g2_a21oi_1
XFILLER_5_482 VPWR VGND sg13g2_decap_8
XFILLER_49_670 VPWR VGND sg13g2_decap_8
Xu_ppwm_u_mem__1175__186 VPWR VGND net186 sg13g2_tiehi
XFILLER_37_854 VPWR VGND sg13g2_decap_8
XFILLER_24_537 VPWR VGND sg13g2_decap_8
XFILLER_32_592 VPWR VGND sg13g2_decap_8
XFILLER_20_776 VPWR VGND sg13g2_decap_8
Xclkload7 clknet_5_22__leaf_clk clkload7/X VPWR VGND sg13g2_buf_1
XFILLER_47_618 VPWR VGND sg13g2_decap_8
XFILLER_28_854 VPWR VGND sg13g2_decap_8
XFILLER_43_813 VPWR VGND sg13g2_decap_8
XFILLER_30_507 VPWR VGND sg13g2_decap_8
XFILLER_11_710 VPWR VGND sg13g2_decap_8
XFILLER_23_581 VPWR VGND sg13g2_decap_8
XFILLER_24_85 VPWR VGND sg13g2_decap_8
XFILLER_10_231 VPWR VGND sg13g2_fill_1
XFILLER_7_736 VPWR VGND sg13g2_decap_8
XFILLER_6_235 VPWR VGND sg13g2_fill_1
XFILLER_11_787 VPWR VGND sg13g2_decap_8
XFILLER_10_297 VPWR VGND sg13g2_fill_2
XFILLER_3_931 VPWR VGND sg13g2_decap_8
XFILLER_2_452 VPWR VGND sg13g2_decap_8
XFILLER_49_82 VPWR VGND sg13g2_decap_8
Xu_ppwm_u_mem__1094__162 VPWR VGND net162 sg13g2_tiehi
XFILLER_1_56 VPWR VGND sg13g2_fill_2
Xu_ppwm_u_ex__1080_ u_ppwm_u_ex__1080_/Y net425 net348 VPWR VGND sg13g2_nand2_1
XFILLER_18_331 VPWR VGND sg13g2_fill_1
XFILLER_19_865 VPWR VGND sg13g2_decap_8
XFILLER_33_301 VPWR VGND sg13g2_fill_1
XFILLER_34_857 VPWR VGND sg13g2_decap_8
Xu_ppwm_u_ex__0933_ u_ppwm_u_ex__0933_/A u_ppwm_u_ex__0933_/B u_ppwm_u_ex__0933_/X
+ VPWR VGND sg13g2_and2_1
XFILLER_33_389 VPWR VGND sg13g2_fill_2
Xu_ppwm_u_ex__0864_ net495 VPWR u_ppwm_u_ex__0865_/A VGND net447 net345 sg13g2_o21ai_1
Xu_ppwm_u_pwm__249_ net216 VGND VPWR net540 hold156/A clknet_5_6__leaf_clk sg13g2_dfrbpq_1
Xu_ppwm_u_ex__0795_ VGND VPWR net647 u_ppwm_u_ex__0785_/Y u_ppwm_u_ex__0795_/Y u_ppwm_u_ex__0794_/Y
+ sg13g2_a21oi_1
XFILLER_46_0 VPWR VGND sg13g2_decap_8
Xu_ppwm_u_mem__1142__185 VPWR VGND net185 sg13g2_tiehi
Xhold19 hold19/A VPWR VGND net236 sg13g2_dlygate4sd3_1
XFILLER_28_128 VPWR VGND sg13g2_fill_1
XFILLER_25_802 VPWR VGND sg13g2_decap_8
XFILLER_37_651 VPWR VGND sg13g2_decap_8
XFILLER_25_879 VPWR VGND sg13g2_decap_8
XFILLER_40_849 VPWR VGND sg13g2_decap_8
XFILLER_20_573 VPWR VGND sg13g2_decap_8
XFILLER_4_739 VPWR VGND sg13g2_decap_8
XFILLER_3_249 VPWR VGND sg13g2_fill_1
XFILLER_0_945 VPWR VGND sg13g2_decap_8
XFILLER_48_905 VPWR VGND sg13g2_decap_8
XFILLER_47_404 VPWR VGND sg13g2_decap_8
XFILLER_47_415 VPWR VGND sg13g2_decap_8
XFILLER_19_117 VPWR VGND sg13g2_decap_4
XFILLER_28_651 VPWR VGND sg13g2_decap_8
XFILLER_43_610 VPWR VGND sg13g2_decap_8
XFILLER_16_835 VPWR VGND sg13g2_decap_8
XFILLER_15_345 VPWR VGND sg13g2_decap_8
XFILLER_43_687 VPWR VGND sg13g2_decap_8
XFILLER_15_367 VPWR VGND sg13g2_decap_8
XFILLER_30_304 VPWR VGND sg13g2_decap_8
XFILLER_30_315 VPWR VGND sg13g2_decap_8
XFILLER_30_326 VPWR VGND sg13g2_fill_2
XFILLER_31_838 VPWR VGND sg13g2_decap_8
Xu_ppwm_u_mem__0930_ VGND VPWR u_ppwm_u_mem__0667_/Y net411 hold108/A u_ppwm_u_mem__0929_/Y
+ sg13g2_a21oi_1
XFILLER_7_533 VPWR VGND sg13g2_decap_8
Xu_ppwm_u_global_counter__168__70 VPWR VGND net70 sg13g2_tiehi
XFILLER_11_584 VPWR VGND sg13g2_decap_8
Xu_ppwm_u_mem__0861_ net490 VPWR u_ppwm_u_mem__0861_/Y VGND net515 net393 sg13g2_o21ai_1
Xu_ppwm_u_ex__0580_ u_ppwm_u_ex__0715_/A net443 VPWR VGND sg13g2_inv_2
Xu_ppwm_u_mem__0792_ net453 u_ppwm_u_mem__0792_/B u_ppwm_u_mem__0792_/Y VPWR VGND
+ sg13g2_nor2_1
XFILLER_39_927 VPWR VGND sg13g2_decap_8
XFILLER_2_293 VPWR VGND sg13g2_fill_1
Xu_ppwm_u_global_counter__121_ net429 u_ppwm_u_global_counter__121_/B u_ppwm_u_global_counter__132_/C
+ u_ppwm_u_global_counter__166_/D VPWR VGND sg13g2_nor3_1
XFILLER_18_4 VPWR VGND sg13g2_fill_1
Xu_ppwm_u_ex__1132_ net32 VGND VPWR net648 hold264/A clknet_5_19__leaf_clk sg13g2_dfrbpq_2
XFILLER_20_1000 VPWR VGND sg13g2_decap_8
Xu_ppwm_u_ex__1063_ net364 net433 u_ppwm_u_ex__1087_/A VPWR VGND sg13g2_xor2_1
XFILLER_47_982 VPWR VGND sg13g2_decap_8
XFILLER_19_662 VPWR VGND sg13g2_decap_8
XFILLER_22_805 VPWR VGND sg13g2_decap_8
XFILLER_34_654 VPWR VGND sg13g2_decap_8
XFILLER_21_337 VPWR VGND sg13g2_fill_1
Xu_ppwm_u_ex__0916_ net360 u_ppwm_u_ex__0935_/B u_ppwm_u_ex__0916_/Y VPWR VGND sg13g2_nor2_1
XFILLER_30_871 VPWR VGND sg13g2_decap_8
Xu_ppwm_u_ex__0847_ u_ppwm_u_ex__0872_/B u_ppwm_u_ex__0873_/A u_ppwm_u_ex__0847_/B
+ VPWR VGND sg13g2_nand2_1
Xu_ppwm_u_ex__0778_ u_ppwm_u_ex__0779_/B net475 u_ppwm_u_ex__0925_/B u_ppwm_u_ex__0778_/C
+ VPWR VGND sg13g2_and3_1
Xu_ppwm_u_mem__1188__98 VPWR VGND net98 sg13g2_tiehi
XFILLER_13_805 VPWR VGND sg13g2_decap_8
XFILLER_25_676 VPWR VGND sg13g2_decap_8
XFILLER_24_186 VPWR VGND sg13g2_decap_4
XFILLER_40_646 VPWR VGND sg13g2_decap_8
XFILLER_4_536 VPWR VGND sg13g2_decap_8
XFILLER_21_75 VPWR VGND sg13g2_decap_4
XFILLER_48_702 VPWR VGND sg13g2_decap_8
XFILLER_0_742 VPWR VGND sg13g2_decap_8
XFILLER_48_779 VPWR VGND sg13g2_decap_8
Xu_ppwm_u_mem__1060_ net381 u_ppwm_u_mem__1075_/B u_ppwm_u_mem__1060_/X VPWR VGND
+ sg13g2_and2_1
XFILLER_46_72 VPWR VGND sg13g2_fill_1
XFILLER_16_632 VPWR VGND sg13g2_decap_8
XFILLER_44_985 VPWR VGND sg13g2_decap_8
XFILLER_43_484 VPWR VGND sg13g2_decap_8
XFILLER_31_635 VPWR VGND sg13g2_decap_8
Xu_ppwm_u_mem__0913_ net501 VPWR u_ppwm_u_mem__0913_/Y VGND net533 net413 sg13g2_o21ai_1
XFILLER_8_864 VPWR VGND sg13g2_decap_8
XFILLER_11_381 VPWR VGND sg13g2_fill_2
Xu_ppwm_u_ex__0701_ fanout359/A net372 net360 VPWR VGND sg13g2_nand2_2
Xu_ppwm_u_mem__0844_ VGND VPWR u_ppwm_u_mem__0710_/Y net395 u_ppwm_u_mem__1092_/D
+ u_ppwm_u_mem__0843_/Y sg13g2_a21oi_1
Xu_ppwm_u_ex__0632_ net373 net458 u_ppwm_u_ex__0634_/C VPWR VGND sg13g2_xor2_1
XFILLER_7_385 VPWR VGND sg13g2_decap_4
Xu_ppwm_u_mem__0775_ net465 hold171/A hold184/A hold98/A hold32/A net457 u_ppwm_u_mem__0776_/B
+ VPWR VGND sg13g2_mux4_1
XFILLER_39_724 VPWR VGND sg13g2_decap_8
Xu_ppwm_u_global_counter__104_ u_ppwm_u_global_counter__105_/B net495 u_ppwm_u_global_counter__106_/B
+ VPWR VGND sg13g2_nand2_1
Xu_ppwm_u_ex__1115_ net28 VGND VPWR u_ppwm_u_ex__1115_/D hold233/A clknet_5_17__leaf_clk
+ sg13g2_dfrbpq_1
Xu_ppwm_u_ex__1046_ u_ppwm_u_ex__1046_/Y net347 net423 fanout359/A net445 VPWR VGND
+ sg13g2_a22oi_1
XFILLER_22_602 VPWR VGND sg13g2_decap_8
Xu_ppwm_u_mem__1189_ net90 VGND VPWR u_ppwm_u_mem__1189_/D hold163/A clknet_5_25__leaf_clk
+ sg13g2_dfrbpq_1
XFILLER_35_996 VPWR VGND sg13g2_decap_8
XFILLER_21_123 VPWR VGND sg13g2_decap_4
XFILLER_22_679 VPWR VGND sg13g2_decap_8
XFILLER_1_517 VPWR VGND sg13g2_decap_8
XFILLER_29_201 VPWR VGND sg13g2_decap_8
XFILLER_44_215 VPWR VGND sg13g2_fill_1
XFILLER_26_963 VPWR VGND sg13g2_decap_8
XFILLER_41_944 VPWR VGND sg13g2_decap_8
XFILLER_13_602 VPWR VGND sg13g2_decap_8
XFILLER_25_473 VPWR VGND sg13g2_decap_8
XFILLER_13_679 VPWR VGND sg13g2_decap_8
XFILLER_5_867 VPWR VGND sg13g2_decap_8
XFILLER_48_576 VPWR VGND sg13g2_decap_8
Xu_ppwm_u_mem__1112_ net126 VGND VPWR u_ppwm_u_mem__1112_/D hold144/A clknet_5_14__leaf_clk
+ sg13g2_dfrbpq_1
Xu_ppwm_u_mem__1190__82 VPWR VGND net82 sg13g2_tiehi
XFILLER_17_930 VPWR VGND sg13g2_decap_8
XFILLER_32_900 VPWR VGND sg13g2_decap_8
Xu_ppwm_u_mem__1043_ net498 VPWR u_ppwm_u_mem__1043_/Y VGND net241 net407 sg13g2_o21ai_1
XFILLER_44_782 VPWR VGND sg13g2_decap_8
XFILLER_32_977 VPWR VGND sg13g2_decap_8
XFILLER_8_661 VPWR VGND sg13g2_decap_8
Xhold116 hold116/A VPWR VGND net333 sg13g2_dlygate4sd3_1
Xhold105 hold105/A VPWR VGND net322 sg13g2_dlygate4sd3_1
Xhold149 hold149/A VPWR VGND net532 sg13g2_dlygate4sd3_1
Xu_ppwm_u_mem__0827_ hold164/A hold172/A net472 u_ppwm_u_mem__0827_/X VPWR VGND sg13g2_mux2_1
Xu_ppwm_u_ex__0615_ u_ppwm_u_ex__0782_/A net591 u_ppwm_u_ex__1114_/D VPWR VGND sg13g2_nor2_1
Xhold127 hold127/A VPWR VGND net510 sg13g2_dlygate4sd3_1
Xhold138 hold138/A VPWR VGND net521 sg13g2_dlygate4sd3_1
Xu_ppwm_u_mem__0758_ net454 VPWR u_ppwm_u_mem__0758_/Y VGND u_ppwm_u_mem__0753_/Y
+ u_ppwm_u_mem__0754_/Y sg13g2_o21ai_1
Xu_ppwm_u_mem__0689_ VPWR u_ppwm_u_mem__0689_/Y net291 VGND sg13g2_inv_1
XFILLER_39_521 VPWR VGND sg13g2_decap_8
XFILLER_2_1019 VPWR VGND sg13g2_decap_8
XFILLER_39_598 VPWR VGND sg13g2_decap_8
Xu_ppwm_u_ex__1029_ u_ppwm_u_ex__1028_/Y VPWR u_ppwm_u_ex__1033_/C VGND u_ppwm_u_ex__1026_/Y
+ u_ppwm_u_ex__1040_/B sg13g2_o21ai_1
XFILLER_35_793 VPWR VGND sg13g2_decap_8
XFILLER_22_421 VPWR VGND sg13g2_fill_2
XFILLER_23_966 VPWR VGND sg13g2_decap_8
Xu_ppwm_u_mem__1185__122 VPWR VGND net122 sg13g2_tiehi
XFILLER_22_476 VPWR VGND sg13g2_decap_8
XFILLER_10_649 VPWR VGND sg13g2_decap_8
XFILLER_2_837 VPWR VGND sg13g2_decap_8
XFILLER_40_1003 VPWR VGND sg13g2_decap_8
XFILLER_45_557 VPWR VGND sg13g2_decap_8
XFILLER_14_933 VPWR VGND sg13g2_decap_8
XFILLER_26_760 VPWR VGND sg13g2_decap_8
XFILLER_32_207 VPWR VGND sg13g2_fill_2
XFILLER_41_741 VPWR VGND sg13g2_decap_8
XFILLER_5_664 VPWR VGND sg13g2_decap_8
Xu_ppwm_u_mem__0612_ VPWR u_ppwm_u_mem__0612_/Y net280 VGND sg13g2_inv_1
XFILLER_1_881 VPWR VGND sg13g2_decap_8
XFILLER_49_852 VPWR VGND sg13g2_decap_8
XFILLER_24_719 VPWR VGND sg13g2_decap_8
XFILLER_36_557 VPWR VGND sg13g2_decap_8
Xu_ppwm_u_mem__1026_ VGND VPWR u_ppwm_u_mem__0619_/Y net416 u_ppwm_u_mem__1183_/D
+ u_ppwm_u_mem__1025_/Y sg13g2_a21oi_1
XFILLER_31_240 VPWR VGND sg13g2_decap_8
XFILLER_32_774 VPWR VGND sg13g2_decap_8
XFILLER_20_958 VPWR VGND sg13g2_decap_8
XFILLER_31_284 VPWR VGND sg13g2_fill_1
Xfanout404 fanout421/A net404 VPWR VGND sg13g2_buf_2
Xfanout415 net420 net415 VPWR VGND sg13g2_buf_8
Xfanout426 net651 net426 VPWR VGND sg13g2_buf_8
Xfanout448 net449 net448 VPWR VGND sg13g2_buf_8
Xfanout437 hold244/A net437 VPWR VGND sg13g2_buf_8
Xfanout459 net460 net459 VPWR VGND sg13g2_buf_8
Xu_ppwm_u_mem__1191__192 VPWR VGND net192 sg13g2_tiehi
XFILLER_27_568 VPWR VGND sg13g2_decap_8
XFILLER_42_538 VPWR VGND sg13g2_decap_8
XFILLER_35_590 VPWR VGND sg13g2_decap_8
XFILLER_23_763 VPWR VGND sg13g2_decap_8
XFILLER_13_21 VPWR VGND sg13g2_fill_1
XFILLER_22_262 VPWR VGND sg13g2_fill_2
XFILLER_7_918 VPWR VGND sg13g2_decap_8
XFILLER_11_969 VPWR VGND sg13g2_decap_8
XFILLER_6_428 VPWR VGND sg13g2_decap_8
XFILLER_2_634 VPWR VGND sg13g2_decap_8
XFILLER_1_166 VPWR VGND sg13g2_decap_8
XFILLER_1_144 VPWR VGND sg13g2_decap_4
Xu_ppwm_u_mem__1200__188 VPWR VGND net188 sg13g2_tiehi
XFILLER_1_177 VPWR VGND sg13g2_fill_2
XFILLER_46_811 VPWR VGND sg13g2_decap_8
XFILLER_18_557 VPWR VGND sg13g2_decap_8
XFILLER_46_888 VPWR VGND sg13g2_decap_8
XFILLER_14_730 VPWR VGND sg13g2_decap_8
Xu_ppwm_u_ex__0880_ net352 u_ppwm_u_ex__0880_/B u_ppwm_u_ex__0880_/Y VPWR VGND sg13g2_nor2_1
Xu_ppwm_u_ex__1125__52 VPWR VGND net52 sg13g2_tiehi
Xu_ppwm_u_pwm__196_ net481 VPWR u_ppwm_u_pwm__196_/Y VGND net441 net380 sg13g2_o21ai_1
XFILLER_6_995 VPWR VGND sg13g2_decap_8
XFILLER_5_461 VPWR VGND sg13g2_decap_8
XFILLER_37_833 VPWR VGND sg13g2_decap_8
XFILLER_24_516 VPWR VGND sg13g2_decap_8
Xu_ppwm_u_mem__1009_ net503 VPWR u_ppwm_u_mem__1009_/Y VGND hold145/A net417 sg13g2_o21ai_1
XFILLER_32_571 VPWR VGND sg13g2_decap_8
Xclkload8 VPWR clkload8/Y clknet_5_25__leaf_clk VGND sg13g2_inv_1
XFILLER_20_755 VPWR VGND sg13g2_decap_8
XFILLER_8_1025 VPWR VGND sg13g2_decap_4
XFILLER_28_833 VPWR VGND sg13g2_decap_8
XFILLER_27_343 VPWR VGND sg13g2_fill_2
XFILLER_39_181 VPWR VGND sg13g2_decap_4
XFILLER_42_302 VPWR VGND sg13g2_fill_2
XFILLER_27_376 VPWR VGND sg13g2_fill_2
XFILLER_43_869 VPWR VGND sg13g2_decap_8
XFILLER_15_549 VPWR VGND sg13g2_decap_8
XFILLER_23_560 VPWR VGND sg13g2_decap_8
XFILLER_24_64 VPWR VGND sg13g2_fill_2
XFILLER_7_715 VPWR VGND sg13g2_decap_8
XFILLER_11_766 VPWR VGND sg13g2_decap_8
XFILLER_40_52 VPWR VGND sg13g2_fill_1
XFILLER_3_910 VPWR VGND sg13g2_decap_8
XFILLER_6_0 VPWR VGND sg13g2_fill_2
XFILLER_2_431 VPWR VGND sg13g2_decap_8
XFILLER_3_987 VPWR VGND sg13g2_decap_8
XFILLER_1_35 VPWR VGND sg13g2_decap_8
XFILLER_19_844 VPWR VGND sg13g2_decap_8
XFILLER_46_685 VPWR VGND sg13g2_decap_8
XFILLER_34_836 VPWR VGND sg13g2_decap_8
Xu_ppwm_u_mem__1133__85 VPWR VGND net85 sg13g2_tiehi
XFILLER_33_324 VPWR VGND sg13g2_fill_1
XFILLER_21_519 VPWR VGND sg13g2_decap_8
Xu_ppwm_u_ex__0932_ VGND VPWR u_ppwm_u_ex__0927_/A u_ppwm_u_ex__0930_/Y u_ppwm_u_ex__0941_/A
+ u_ppwm_u_ex__0931_/Y sg13g2_a21oi_1
Xu_ppwm_u_ex__0863_ u_ppwm_u_ex__0863_/B u_ppwm_u_ex__0863_/C net346 u_ppwm_u_ex__0863_/Y
+ VPWR VGND u_ppwm_u_ex__0863_/D sg13g2_nand4_1
Xu_ppwm_u_pwm__248_ net198 VGND VPWR net579 hold195/A clknet_5_6__leaf_clk sg13g2_dfrbpq_1
Xu_ppwm_u_ex__0794_ u_ppwm_u_ex__0793_/Y VPWR u_ppwm_u_ex__0794_/Y VGND net353 u_ppwm_u_ex__0786_/Y
+ sg13g2_o21ai_1
Xu_ppwm_u_pwm__179_ u_ppwm_u_pwm__179_/B u_ppwm_u_pwm__179_/C u_ppwm_u_pwm__179_/A
+ fanout380/A VPWR VGND sg13g2_nand3_1
XFILLER_6_792 VPWR VGND sg13g2_decap_8
XFILLER_39_0 VPWR VGND sg13g2_decap_8
XFILLER_29_619 VPWR VGND sg13g2_decap_8
Xinput1 ui_in[0] net1 VPWR VGND sg13g2_buf_1
XFILLER_37_630 VPWR VGND sg13g2_decap_8
XFILLER_24_324 VPWR VGND sg13g2_decap_8
XFILLER_25_858 VPWR VGND sg13g2_decap_8
XFILLER_40_828 VPWR VGND sg13g2_decap_8
XFILLER_20_552 VPWR VGND sg13g2_decap_8
XFILLER_4_718 VPWR VGND sg13g2_decap_8
XFILLER_10_99 VPWR VGND sg13g2_fill_2
XFILLER_0_924 VPWR VGND sg13g2_decap_8
XFILLER_28_630 VPWR VGND sg13g2_decap_8
XFILLER_16_814 VPWR VGND sg13g2_decap_8
XFILLER_43_666 VPWR VGND sg13g2_decap_8
XFILLER_31_817 VPWR VGND sg13g2_decap_8
XFILLER_37_1008 VPWR VGND sg13g2_decap_8
XFILLER_24_880 VPWR VGND sg13g2_decap_8
XFILLER_7_512 VPWR VGND sg13g2_decap_8
XFILLER_11_563 VPWR VGND sg13g2_decap_8
Xu_ppwm_u_mem__0860_ VGND VPWR u_ppwm_u_mem__0702_/Y net392 hold187/A u_ppwm_u_mem__0859_/Y
+ sg13g2_a21oi_1
XFILLER_7_589 VPWR VGND sg13g2_decap_8
Xu_ppwm_u_mem__0791_ net465 hold138/A hold182/A hold101/A hold158/A net457 u_ppwm_u_mem__0792_/B
+ VPWR VGND sg13g2_mux4_1
XFILLER_3_784 VPWR VGND sg13g2_decap_8
XFILLER_32_7 VPWR VGND sg13g2_decap_4
XFILLER_39_906 VPWR VGND sg13g2_decap_8
Xu_ppwm_u_global_counter__120_ u_ppwm_u_global_counter__120_/A u_ppwm_u_global_counter__120_/B
+ u_ppwm_u_global_counter__120_/C u_ppwm_u_global_counter__132_/C VGND VPWR u_ppwm_u_global_counter__120_/D
+ sg13g2_nor4_2
XFILLER_25_6 VPWR VGND sg13g2_fill_1
Xu_ppwm_u_ex__1131_ net36 VGND VPWR u_ppwm_u_ex__1131_/D hold271/A clknet_5_7__leaf_clk
+ sg13g2_dfrbpq_2
XFILLER_19_641 VPWR VGND sg13g2_decap_8
Xu_ppwm_u_ex__1062_ net433 net364 u_ppwm_u_ex__1077_/A VPWR VGND sg13g2_and2_1
XFILLER_47_961 VPWR VGND sg13g2_decap_8
XFILLER_46_482 VPWR VGND sg13g2_decap_8
XFILLER_34_633 VPWR VGND sg13g2_decap_8
XFILLER_21_316 VPWR VGND sg13g2_fill_2
Xu_ppwm_u_ex__0915_ u_ppwm_u_ex__0914_/Y VPWR u_ppwm_u_ex__0935_/B VGND u_ppwm_u_ex__0719_/A
+ net376 sg13g2_o21ai_1
XFILLER_30_850 VPWR VGND sg13g2_decap_8
Xu_ppwm_u_ex__0846_ u_ppwm_u_ex__0846_/A u_ppwm_u_ex__0933_/B u_ppwm_u_ex__0966_/A
+ VPWR VGND sg13g2_nor2_2
Xu_ppwm_u_ex__0777_ VPWR VGND u_ppwm_u_ex__0677_/X u_ppwm_u_ex__0782_/A u_ppwm_u_ex__0776_/X
+ u_ppwm_u_ex__0625_/A hold130/A u_ppwm_u_ex__0678_/Y sg13g2_a221oi_1
Xu_ppwm_u_mem__0989_ net481 VPWR u_ppwm_u_mem__0989_/Y VGND net256 net387 sg13g2_o21ai_1
XFILLER_5_1028 VPWR VGND sg13g2_fill_1
XFILLER_38_994 VPWR VGND sg13g2_decap_8
XFILLER_25_655 VPWR VGND sg13g2_decap_8
XFILLER_40_625 VPWR VGND sg13g2_decap_8
XFILLER_21_883 VPWR VGND sg13g2_decap_8
XFILLER_4_515 VPWR VGND sg13g2_decap_8
XFILLER_0_721 VPWR VGND sg13g2_decap_8
XFILLER_43_1023 VPWR VGND sg13g2_decap_4
XFILLER_0_798 VPWR VGND sg13g2_decap_8
XFILLER_48_758 VPWR VGND sg13g2_decap_8
XFILLER_29_983 VPWR VGND sg13g2_decap_8
XFILLER_16_611 VPWR VGND sg13g2_decap_8
XFILLER_44_964 VPWR VGND sg13g2_decap_8
XFILLER_43_463 VPWR VGND sg13g2_decap_8
Xclkbuf_5_0__f_clk clknet_4_0_0_clk clknet_5_0__leaf_clk VPWR VGND sg13g2_buf_8
XFILLER_15_154 VPWR VGND sg13g2_fill_1
XFILLER_16_688 VPWR VGND sg13g2_decap_8
XFILLER_31_614 VPWR VGND sg13g2_decap_8
Xu_ppwm_u_mem__0912_ VGND VPWR u_ppwm_u_mem__0676_/Y net413 hold111/A u_ppwm_u_mem__0911_/Y
+ sg13g2_a21oi_1
Xu_ppwm_u_ex__0700_ u_ppwm_u_ex__0699_/Y VPWR u_ppwm_u_ex__0700_/Y VGND u_ppwm_u_ex__0691_/Y
+ u_ppwm_u_ex__0693_/Y sg13g2_o21ai_1
XFILLER_8_843 VPWR VGND sg13g2_decap_8
Xu_ppwm_u_mem__0843_ net486 VPWR u_ppwm_u_mem__0843_/Y VGND net305 net392 sg13g2_o21ai_1
Xu_ppwm_u_ex__0631_ u_ppwm_u_ex__0642_/A net458 net373 VPWR VGND sg13g2_nand2_1
Xu_ppwm_u_mem__0774_ net454 VPWR u_ppwm_u_mem__0774_/Y VGND u_ppwm_u_mem__0769_/Y
+ u_ppwm_u_mem__0770_/Y sg13g2_o21ai_1
XFILLER_3_581 VPWR VGND sg13g2_decap_8
XFILLER_30_4 VPWR VGND sg13g2_decap_8
XFILLER_39_703 VPWR VGND sg13g2_decap_8
Xu_ppwm_u_global_counter__103_ net599 net428 net614 u_ppwm_u_global_counter__106_/B
+ VPWR VGND sg13g2_nand3_1
Xu_ppwm_u_ex__1114_ net49 VGND VPWR u_ppwm_u_ex__1114_/D hold207/A clknet_5_17__leaf_clk
+ sg13g2_dfrbpq_1
Xu_ppwm_u_ex__1045_ u_ppwm_u_ex__1045_/Y hold279/A fanout348/A VPWR VGND sg13g2_nand2_1
XFILLER_35_975 VPWR VGND sg13g2_decap_8
Xu_ppwm_u_mem__1188_ net98 VGND VPWR net537 hold153/A clknet_5_27__leaf_clk sg13g2_dfrbpq_1
XFILLER_22_658 VPWR VGND sg13g2_decap_8
Xu_ppwm_u_mem__1109__132 VPWR VGND net132 sg13g2_tiehi
Xu_ppwm_u_ex__0829_ VGND VPWR u_ppwm_u_ex__0827_/Y u_ppwm_u_ex__0828_/Y u_ppwm_u_ex__1010_/A
+ u_ppwm_u_ex__0804_/C sg13g2_a21oi_1
XFILLER_29_257 VPWR VGND sg13g2_fill_1
XFILLER_45_739 VPWR VGND sg13g2_decap_8
XFILLER_26_942 VPWR VGND sg13g2_decap_8
XFILLER_38_791 VPWR VGND sg13g2_decap_8
XFILLER_25_452 VPWR VGND sg13g2_decap_8
XFILLER_41_923 VPWR VGND sg13g2_decap_8
XFILLER_13_658 VPWR VGND sg13g2_decap_8
XFILLER_40_499 VPWR VGND sg13g2_decap_8
XFILLER_21_680 VPWR VGND sg13g2_decap_8
XFILLER_32_42 VPWR VGND sg13g2_fill_1
XFILLER_5_846 VPWR VGND sg13g2_decap_8
XFILLER_0_595 VPWR VGND sg13g2_decap_8
XFILLER_48_555 VPWR VGND sg13g2_decap_8
Xu_ppwm_u_mem__1111_ net128 VGND VPWR u_ppwm_u_mem__1111_/D hold149/A clknet_5_14__leaf_clk
+ sg13g2_dfrbpq_1
XFILLER_29_780 VPWR VGND sg13g2_decap_8
XFILLER_36_739 VPWR VGND sg13g2_decap_8
Xu_ppwm_u_mem__1042_ VGND VPWR u_ppwm_u_mem__0611_/Y net407 u_ppwm_u_mem__1191_/D
+ u_ppwm_u_mem__1041_/Y sg13g2_a21oi_1
XFILLER_44_761 VPWR VGND sg13g2_decap_8
XFILLER_16_463 VPWR VGND sg13g2_fill_1
XFILLER_17_986 VPWR VGND sg13g2_decap_8
XFILLER_32_956 VPWR VGND sg13g2_decap_8
XFILLER_8_640 VPWR VGND sg13g2_decap_8
XFILLER_31_488 VPWR VGND sg13g2_decap_8
Xu_ppwm_u_mem__0826_ hold10/A hold175/A net472 u_ppwm_u_mem__0826_/X VPWR VGND sg13g2_mux2_1
XFILLER_7_183 VPWR VGND sg13g2_decap_8
Xu_ppwm_u_ex__0614_ hold208/A u_ppwm_u_ex__0622_/B net475 u_ppwm_u_ex__0623_/A net590
+ VPWR VGND sg13g2_a22oi_1
Xhold106 hold106/A VPWR VGND net323 sg13g2_dlygate4sd3_1
Xhold117 hold117/A VPWR VGND net334 sg13g2_dlygate4sd3_1
Xhold128 hold128/A VPWR VGND net511 sg13g2_dlygate4sd3_1
Xhold139 hold139/A VPWR VGND net522 sg13g2_dlygate4sd3_1
Xu_ppwm_u_mem__0757_ VGND VPWR u_ppwm_u_mem__0755_/Y u_ppwm_u_mem__0756_/Y u_ppwm_u_mem__0757_/Y
+ net459 sg13g2_a21oi_1
Xu_ppwm_u_mem__0688_ VPWR u_ppwm_u_mem__0688_/Y net556 VGND sg13g2_inv_1
XFILLER_39_500 VPWR VGND sg13g2_decap_8
XFILLER_39_577 VPWR VGND sg13g2_decap_8
Xu_ppwm_u_ex__1028_ VGND VPWR u_ppwm_u_ex__1026_/Y u_ppwm_u_ex__1040_/B u_ppwm_u_ex__1028_/Y
+ net349 sg13g2_a21oi_1
XFILLER_35_772 VPWR VGND sg13g2_decap_8
XFILLER_23_945 VPWR VGND sg13g2_decap_8
XFILLER_10_628 VPWR VGND sg13g2_decap_8
XFILLER_2_816 VPWR VGND sg13g2_decap_8
XFILLER_45_536 VPWR VGND sg13g2_decap_8
XFILLER_17_205 VPWR VGND sg13g2_decap_8
XFILLER_18_739 VPWR VGND sg13g2_decap_8
XFILLER_14_912 VPWR VGND sg13g2_decap_8
XFILLER_41_720 VPWR VGND sg13g2_decap_8
XFILLER_13_411 VPWR VGND sg13g2_decap_4
XFILLER_14_989 VPWR VGND sg13g2_decap_8
XFILLER_41_797 VPWR VGND sg13g2_decap_8
XFILLER_5_643 VPWR VGND sg13g2_decap_8
Xu_ppwm_u_mem__0611_ VPWR u_ppwm_u_mem__0611_/Y net514 VGND sg13g2_inv_1
XFILLER_4_186 VPWR VGND sg13g2_fill_2
XFILLER_1_860 VPWR VGND sg13g2_decap_8
XFILLER_49_831 VPWR VGND sg13g2_decap_8
XFILLER_0_392 VPWR VGND sg13g2_decap_8
XFILLER_36_536 VPWR VGND sg13g2_decap_8
XFILLER_16_260 VPWR VGND sg13g2_decap_8
XFILLER_17_783 VPWR VGND sg13g2_decap_8
XFILLER_23_208 VPWR VGND sg13g2_decap_8
XFILLER_23_219 VPWR VGND sg13g2_fill_1
Xu_ppwm_u_mem__1025_ net503 VPWR u_ppwm_u_mem__1025_/Y VGND net260 net416 sg13g2_o21ai_1
XFILLER_17_1028 VPWR VGND sg13g2_fill_1
XFILLER_32_753 VPWR VGND sg13g2_decap_8
XFILLER_20_937 VPWR VGND sg13g2_decap_8
XFILLER_31_263 VPWR VGND sg13g2_decap_4
Xu_ppwm_u_mem__0809_ net452 VPWR u_ppwm_u_mem__0809_/Y VGND u_ppwm_u_mem__0805_/Y
+ u_ppwm_u_mem__0806_/Y sg13g2_o21ai_1
Xfanout405 net421 net405 VPWR VGND sg13g2_buf_8
Xfanout427 net662 net427 VPWR VGND sg13g2_buf_8
Xfanout438 hold303/A net438 VPWR VGND sg13g2_buf_8
Xfanout416 net420 net416 VPWR VGND sg13g2_buf_8
Xfanout449 net684 net449 VPWR VGND sg13g2_buf_1
XFILLER_27_547 VPWR VGND sg13g2_decap_8
XFILLER_42_517 VPWR VGND sg13g2_decap_8
XFILLER_23_742 VPWR VGND sg13g2_decap_8
XFILLER_11_948 VPWR VGND sg13g2_decap_8
XFILLER_13_11 VPWR VGND sg13g2_decap_4
XFILLER_6_407 VPWR VGND sg13g2_decap_8
XFILLER_2_613 VPWR VGND sg13g2_decap_8
XFILLER_1_123 VPWR VGND sg13g2_decap_8
XFILLER_49_127 VPWR VGND sg13g2_fill_2
XFILLER_49_116 VPWR VGND sg13g2_fill_2
XFILLER_46_867 VPWR VGND sg13g2_decap_8
XFILLER_45_322 VPWR VGND sg13g2_decap_4
XFILLER_18_536 VPWR VGND sg13g2_decap_8
XFILLER_41_594 VPWR VGND sg13g2_decap_8
XFILLER_13_263 VPWR VGND sg13g2_decap_4
XFILLER_14_786 VPWR VGND sg13g2_decap_8
XFILLER_5_440 VPWR VGND sg13g2_decap_8
XFILLER_10_992 VPWR VGND sg13g2_decap_8
Xu_ppwm_u_pwm__195_ VGND VPWR u_ppwm_u_pwm__130_/Y net380 hold19/A u_ppwm_u_pwm__194_/Y
+ sg13g2_a21oi_1
XFILLER_6_974 VPWR VGND sg13g2_decap_8
XFILLER_37_812 VPWR VGND sg13g2_decap_8
XFILLER_37_889 VPWR VGND sg13g2_decap_8
XFILLER_17_580 VPWR VGND sg13g2_decap_8
Xu_ppwm_u_mem__1008_ VGND VPWR u_ppwm_u_mem__0628_/Y net409 u_ppwm_u_mem__1174_/D
+ u_ppwm_u_mem__1007_/Y sg13g2_a21oi_1
XFILLER_32_550 VPWR VGND sg13g2_decap_8
XFILLER_20_734 VPWR VGND sg13g2_decap_8
Xclkload9 clknet_5_30__leaf_clk clkload9/X VPWR VGND sg13g2_buf_1
XFILLER_30_1025 VPWR VGND sg13g2_decap_4
XFILLER_8_1004 VPWR VGND sg13g2_decap_8
XFILLER_28_812 VPWR VGND sg13g2_decap_8
XFILLER_28_889 VPWR VGND sg13g2_decap_8
XFILLER_43_848 VPWR VGND sg13g2_decap_8
XFILLER_15_528 VPWR VGND sg13g2_decap_8
XFILLER_10_200 VPWR VGND sg13g2_decap_8
XFILLER_11_745 VPWR VGND sg13g2_decap_8
XFILLER_6_204 VPWR VGND sg13g2_decap_4
XFILLER_10_299 VPWR VGND sg13g2_fill_1
XFILLER_2_410 VPWR VGND sg13g2_decap_8
XFILLER_46_1021 VPWR VGND sg13g2_decap_8
XFILLER_3_966 VPWR VGND sg13g2_decap_8
XFILLER_2_487 VPWR VGND sg13g2_decap_8
XFILLER_1_14 VPWR VGND sg13g2_decap_8
XFILLER_38_609 VPWR VGND sg13g2_decap_8
XFILLER_19_823 VPWR VGND sg13g2_decap_8
XFILLER_1_58 VPWR VGND sg13g2_fill_1
XFILLER_46_664 VPWR VGND sg13g2_decap_8
XFILLER_34_815 VPWR VGND sg13g2_decap_8
XFILLER_42_881 VPWR VGND sg13g2_decap_8
Xu_ppwm_u_ex__0931_ net350 VPWR u_ppwm_u_ex__0931_/Y VGND u_ppwm_u_ex__0927_/A u_ppwm_u_ex__0930_/Y
+ sg13g2_o21ai_1
XFILLER_14_583 VPWR VGND sg13g2_decap_8
Xu_ppwm_u_ex__0862_ VGND VPWR net438 u_ppwm_u_ex__0785_/Y u_ppwm_u_ex__0863_/D u_ppwm_u_ex__0861_/Y
+ sg13g2_a21oi_1
Xu_ppwm_u_ex__0793_ u_ppwm_u_ex__0793_/Y u_ppwm_u_ex__0860_/B net372 u_ppwm_u_ex__0791_/X
+ net350 VPWR VGND sg13g2_a22oi_1
Xu_ppwm_u_pwm__247_ net202 VGND VPWR net581 hold197/A clknet_5_4__leaf_clk sg13g2_dfrbpq_1
Xu_ppwm_u_pwm__178_ hold245/A hold236/A hold241/A net583 u_ppwm_u_pwm__179_/C VPWR
+ VGND sg13g2_nor4_1
XFILLER_6_771 VPWR VGND sg13g2_decap_8
Xinput2 ui_in[1] net2 VPWR VGND sg13g2_buf_1
XFILLER_37_686 VPWR VGND sg13g2_decap_8
XFILLER_25_837 VPWR VGND sg13g2_decap_8
XFILLER_40_807 VPWR VGND sg13g2_decap_8
XFILLER_20_531 VPWR VGND sg13g2_decap_8
XFILLER_0_903 VPWR VGND sg13g2_decap_8
XFILLER_43_645 VPWR VGND sg13g2_decap_8
XFILLER_15_325 VPWR VGND sg13g2_fill_2
XFILLER_27_185 VPWR VGND sg13g2_fill_2
XFILLER_28_686 VPWR VGND sg13g2_decap_8
XFILLER_42_133 VPWR VGND sg13g2_fill_2
XFILLER_15_358 VPWR VGND sg13g2_decap_4
XFILLER_11_542 VPWR VGND sg13g2_decap_8
Xclkbuf_5_19__f_clk clknet_4_9_0_clk clknet_5_19__leaf_clk VPWR VGND sg13g2_buf_8
XFILLER_7_568 VPWR VGND sg13g2_decap_8
Xu_ppwm_u_mem__0790_ net454 VPWR u_ppwm_u_mem__0790_/Y VGND u_ppwm_u_mem__0785_/Y
+ u_ppwm_u_mem__0786_/Y sg13g2_o21ai_1
XFILLER_3_763 VPWR VGND sg13g2_decap_8
XFILLER_2_262 VPWR VGND sg13g2_fill_1
Xu_ppwm_u_ex__1130_ net40 VGND VPWR u_ppwm_u_ex__1130_/D hold292/A clknet_5_7__leaf_clk
+ sg13g2_dfrbpq_2
XFILLER_47_940 VPWR VGND sg13g2_decap_8
Xu_ppwm_u_ex__1061_ u_ppwm_u_ex__1061_/A u_ppwm_u_ex__1061_/B u_ppwm_u_ex__1137_/D
+ VPWR VGND sg13g2_nor2_1
XFILLER_19_620 VPWR VGND sg13g2_decap_8
XFILLER_38_439 VPWR VGND sg13g2_decap_4
XFILLER_46_461 VPWR VGND sg13g2_decap_8
XFILLER_19_697 VPWR VGND sg13g2_decap_8
XFILLER_34_612 VPWR VGND sg13g2_decap_8
XFILLER_34_689 VPWR VGND sg13g2_decap_8
XFILLER_15_892 VPWR VGND sg13g2_decap_8
Xu_ppwm_u_ex__0914_ u_ppwm_u_ex__0914_/Y net430 net376 VPWR VGND sg13g2_nand2_1
Xu_ppwm_u_ex__0845_ net374 u_ppwm_u_ex__0845_/C u_ppwm/instr\[0\] u_ppwm_u_ex__0874_/B
+ VPWR VGND sg13g2_nand3_1
Xu_ppwm_u_ex__0776_ u_ppwm_u_ex__0776_/A u_ppwm_u_ex__0776_/B u_ppwm_u_ex__0776_/C
+ u_ppwm_u_ex__0776_/D u_ppwm_u_ex__0776_/X VPWR VGND sg13g2_and4_1
Xu_ppwm_u_mem__0988_ VGND VPWR u_ppwm_u_mem__0638_/Y net391 u_ppwm_u_mem__1164_/D
+ u_ppwm_u_mem__0987_/Y sg13g2_a21oi_1
XFILLER_5_1007 VPWR VGND sg13g2_decap_8
XFILLER_29_439 VPWR VGND sg13g2_fill_2
XFILLER_38_973 VPWR VGND sg13g2_decap_8
Xu_ppwm_u_global_counter__179_ net69 VGND VPWR u_ppwm_u_global_counter__179_/D hold259/A
+ clknet_5_5__leaf_clk sg13g2_dfrbpq_2
XFILLER_25_634 VPWR VGND sg13g2_decap_8
XFILLER_37_483 VPWR VGND sg13g2_decap_8
XFILLER_24_122 VPWR VGND sg13g2_fill_1
XFILLER_40_604 VPWR VGND sg13g2_decap_8
XFILLER_21_862 VPWR VGND sg13g2_decap_8
XFILLER_20_372 VPWR VGND sg13g2_decap_4
XFILLER_20_394 VPWR VGND sg13g2_fill_2
XFILLER_0_700 VPWR VGND sg13g2_decap_8
XFILLER_43_1002 VPWR VGND sg13g2_decap_8
XFILLER_48_737 VPWR VGND sg13g2_decap_8
XFILLER_0_777 VPWR VGND sg13g2_decap_8
XFILLER_29_962 VPWR VGND sg13g2_decap_8
XFILLER_44_943 VPWR VGND sg13g2_decap_8
XFILLER_28_483 VPWR VGND sg13g2_decap_8
XFILLER_43_431 VPWR VGND sg13g2_fill_1
XFILLER_16_667 VPWR VGND sg13g2_decap_8
Xu_ppwm_u_mem__0911_ net501 VPWR u_ppwm_u_mem__0911_/Y VGND hold161/A net413 sg13g2_o21ai_1
XFILLER_8_822 VPWR VGND sg13g2_decap_8
XFILLER_7_332 VPWR VGND sg13g2_fill_2
XFILLER_11_372 VPWR VGND sg13g2_fill_2
XFILLER_12_884 VPWR VGND sg13g2_decap_8
Xu_ppwm_u_mem__0842_ VGND VPWR u_ppwm_u_mem__0711_/Y net394 hold91/A u_ppwm_u_mem__0841_/Y
+ sg13g2_a21oi_1
XFILLER_8_899 VPWR VGND sg13g2_decap_8
Xu_ppwm_u_ex__0630_ u_ppwm_u_ex__0652_/B u_ppwm_u_ex__0617_/Y u_ppwm_u_ex__0995_/A
+ u_ppwm_u_ex__0630_/X VPWR VGND sg13g2_a21o_1
Xu_ppwm_u_mem__0773_ VGND VPWR u_ppwm_u_mem__0771_/Y u_ppwm_u_mem__0772_/Y u_ppwm_u_mem__0773_/Y
+ net459 sg13g2_a21oi_1
XFILLER_3_560 VPWR VGND sg13g2_decap_8
XFILLER_23_4 VPWR VGND sg13g2_decap_8
XFILLER_39_759 VPWR VGND sg13g2_decap_8
Xu_ppwm_u_global_counter__102_ VGND VPWR hold231/A net428 hold217/A net599 sg13g2_a21oi_1
Xu_ppwm_u_ex__1113_ net29 VGND VPWR net604 hold219/A clknet_5_22__leaf_clk sg13g2_dfrbpq_1
Xu_ppwm_u_ex__1044_ u_ppwm_u_ex__1048_/C u_ppwm_u_ex__1052_/B u_ppwm_u_ex__1044_/B
+ VPWR VGND sg13g2_nand2_1
XFILLER_26_409 VPWR VGND sg13g2_decap_4
XFILLER_19_494 VPWR VGND sg13g2_decap_8
XFILLER_35_954 VPWR VGND sg13g2_decap_8
Xu_ppwm_u_mem__1187_ net106 VGND VPWR net285 hold67/A clknet_5_25__leaf_clk sg13g2_dfrbpq_1
XFILLER_22_637 VPWR VGND sg13g2_decap_8
Xu_ppwm_u_ex__0828_ VGND VPWR u_ppwm_u_ex__0797_/Y u_ppwm_u_ex__0823_/X u_ppwm_u_ex__0828_/Y
+ u_ppwm_u_ex__0821_/Y sg13g2_a21oi_1
Xu_ppwm_u_ex__0759_ u_ppwm_u_ex__0760_/A u_ppwm_u_ex__0759_/C u_ppwm_u_ex__0759_/A
+ u_ppwm_u_ex__0759_/Y VPWR VGND sg13g2_nand3_1
XFILLER_45_718 VPWR VGND sg13g2_decap_8
XFILLER_16_11 VPWR VGND sg13g2_decap_8
XFILLER_26_921 VPWR VGND sg13g2_decap_8
XFILLER_38_770 VPWR VGND sg13g2_decap_8
XFILLER_25_431 VPWR VGND sg13g2_decap_8
XFILLER_41_902 VPWR VGND sg13g2_decap_8
XFILLER_26_998 VPWR VGND sg13g2_decap_8
XFILLER_13_637 VPWR VGND sg13g2_decap_8
XFILLER_41_979 VPWR VGND sg13g2_decap_8
XFILLER_40_478 VPWR VGND sg13g2_decap_8
XFILLER_9_619 VPWR VGND sg13g2_decap_8
XFILLER_5_825 VPWR VGND sg13g2_decap_8
Xu_ppwm_u_mem__1203__110 VPWR VGND net110 sg13g2_tiehi
XFILLER_0_574 VPWR VGND sg13g2_decap_8
XFILLER_48_534 VPWR VGND sg13g2_decap_8
Xu_ppwm_u_mem__1110_ net130 VGND VPWR net246 hold28/A clknet_5_14__leaf_clk sg13g2_dfrbpq_1
XFILLER_36_718 VPWR VGND sg13g2_decap_8
XFILLER_44_740 VPWR VGND sg13g2_decap_8
XFILLER_17_965 VPWR VGND sg13g2_decap_8
Xu_ppwm_u_mem__1041_ net498 VPWR u_ppwm_u_mem__1041_/Y VGND net509 net407 sg13g2_o21ai_1
XFILLER_16_475 VPWR VGND sg13g2_fill_2
XFILLER_32_935 VPWR VGND sg13g2_decap_8
XFILLER_12_681 VPWR VGND sg13g2_decap_8
XFILLER_7_140 VPWR VGND sg13g2_fill_2
Xhold107 hold107/A VPWR VGND net324 sg13g2_dlygate4sd3_1
XFILLER_8_696 VPWR VGND sg13g2_decap_8
Xu_ppwm_u_ex__0613_ VPWR u_ppwm_u_ex__0622_/B u_ppwm_u_ex__0620_/B VGND sg13g2_inv_1
Xu_ppwm_u_mem__0825_ net452 VPWR u_ppwm_u_mem__0825_/Y VGND u_ppwm_u_mem__0821_/Y
+ u_ppwm_u_mem__0822_/Y sg13g2_o21ai_1
Xhold118 hold118/A VPWR VGND net335 sg13g2_dlygate4sd3_1
XFILLER_7_195 VPWR VGND sg13g2_decap_4
Xhold129 hold129/A VPWR VGND net512 sg13g2_dlygate4sd3_1
Xu_ppwm_u_mem__0756_ u_ppwm_u_mem__0756_/Y hold168/A net470 VPWR VGND sg13g2_nand2b_1
Xu_ppwm_u_mem__0687_ VPWR u_ppwm_u_mem__0687_/Y net304 VGND sg13g2_inv_1
Xu_ppwm_u_mem__1178__175 VPWR VGND net175 sg13g2_tiehi
XFILLER_39_556 VPWR VGND sg13g2_decap_8
XFILLER_27_729 VPWR VGND sg13g2_decap_8
Xu_ppwm_u_ex__1027_ u_ppwm_u_ex__1040_/B net437 net366 VPWR VGND sg13g2_xnor2_1
XFILLER_35_751 VPWR VGND sg13g2_decap_8
XFILLER_23_924 VPWR VGND sg13g2_decap_8
XFILLER_22_423 VPWR VGND sg13g2_fill_1
XFILLER_10_607 VPWR VGND sg13g2_decap_8
XFILLER_33_1012 VPWR VGND sg13g2_decap_8
XFILLER_18_718 VPWR VGND sg13g2_decap_8
XFILLER_45_515 VPWR VGND sg13g2_decap_8
XFILLER_17_239 VPWR VGND sg13g2_fill_1
XFILLER_27_98 VPWR VGND sg13g2_fill_2
XFILLER_26_795 VPWR VGND sg13g2_decap_8
XFILLER_41_776 VPWR VGND sg13g2_decap_8
XFILLER_14_968 VPWR VGND sg13g2_decap_8
XFILLER_40_286 VPWR VGND sg13g2_fill_2
XFILLER_5_622 VPWR VGND sg13g2_decap_8
Xu_ppwm_u_mem__0610_ VPWR u_ppwm_u_mem__0610_/Y net509 VGND sg13g2_inv_1
XFILLER_5_699 VPWR VGND sg13g2_decap_8
XFILLER_49_810 VPWR VGND sg13g2_decap_8
XFILLER_0_371 VPWR VGND sg13g2_decap_8
XFILLER_48_342 VPWR VGND sg13g2_decap_8
XFILLER_49_887 VPWR VGND sg13g2_decap_8
XFILLER_36_515 VPWR VGND sg13g2_decap_8
XFILLER_1_1021 VPWR VGND sg13g2_decap_8
XFILLER_17_762 VPWR VGND sg13g2_decap_8
Xu_ppwm_u_mem__1024_ VGND VPWR u_ppwm_u_mem__0620_/Y net417 u_ppwm_u_mem__1182_/D
+ u_ppwm_u_mem__1023_/Y sg13g2_a21oi_1
XFILLER_32_732 VPWR VGND sg13g2_decap_8
XFILLER_17_1007 VPWR VGND sg13g2_decap_8
XFILLER_20_916 VPWR VGND sg13g2_decap_8
XFILLER_9_983 VPWR VGND sg13g2_decap_8
XFILLER_8_493 VPWR VGND sg13g2_decap_8
Xu_ppwm_u_mem__0808_ net453 u_ppwm_u_mem__0808_/B u_ppwm_u_mem__0808_/Y VPWR VGND
+ sg13g2_nor2_1
Xu_ppwm_u_mem__0739_ u_ppwm_u_mem__0739_/Y hold162/A net468 VPWR VGND sg13g2_nand2_1
Xfanout428 fanout428/A net428 VPWR VGND sg13g2_buf_8
Xfanout439 net686 net439 VPWR VGND sg13g2_buf_1
Xfanout406 net407 net406 VPWR VGND sg13g2_buf_1
Xfanout417 net420 net417 VPWR VGND sg13g2_buf_2
XFILLER_27_526 VPWR VGND sg13g2_decap_8
XFILLER_23_721 VPWR VGND sg13g2_decap_8
XFILLER_11_927 VPWR VGND sg13g2_decap_8
XFILLER_22_264 VPWR VGND sg13g2_fill_1
XFILLER_22_286 VPWR VGND sg13g2_fill_1
XFILLER_23_798 VPWR VGND sg13g2_decap_8
XFILLER_10_459 VPWR VGND sg13g2_fill_2
XFILLER_1_102 VPWR VGND sg13g2_decap_8
XFILLER_2_669 VPWR VGND sg13g2_decap_8
XFILLER_18_515 VPWR VGND sg13g2_decap_8
XFILLER_46_846 VPWR VGND sg13g2_decap_8
XFILLER_45_345 VPWR VGND sg13g2_fill_2
XFILLER_26_592 VPWR VGND sg13g2_decap_8
XFILLER_33_529 VPWR VGND sg13g2_decap_8
Xu_ppwm_u_pwm__235__207 VPWR VGND net207 sg13g2_tiehi
XFILLER_14_765 VPWR VGND sg13g2_decap_8
XFILLER_41_573 VPWR VGND sg13g2_decap_8
XFILLER_9_213 VPWR VGND sg13g2_fill_2
XFILLER_13_297 VPWR VGND sg13g2_fill_2
XFILLER_10_971 VPWR VGND sg13g2_decap_8
XFILLER_6_953 VPWR VGND sg13g2_decap_8
Xu_ppwm_u_pwm__194_ net479 VPWR u_ppwm_u_pwm__194_/Y VGND hold276/A net380 sg13g2_o21ai_1
XFILLER_5_496 VPWR VGND sg13g2_decap_8
XFILLER_23_1022 VPWR VGND sg13g2_decap_8
XFILLER_49_684 VPWR VGND sg13g2_decap_8
XFILLER_37_868 VPWR VGND sg13g2_decap_8
Xu_ppwm_u_mem__1007_ net504 VPWR u_ppwm_u_mem__1007_/Y VGND net301 net409 sg13g2_o21ai_1
XFILLER_20_713 VPWR VGND sg13g2_decap_8
Xu_ppwm_u_ex__1116__43 VPWR VGND net43 sg13g2_tiehi
XFILLER_9_780 VPWR VGND sg13g2_decap_8
XFILLER_30_1004 VPWR VGND sg13g2_decap_8
XFILLER_46_109 VPWR VGND sg13g2_fill_2
XFILLER_28_868 VPWR VGND sg13g2_decap_8
XFILLER_43_827 VPWR VGND sg13g2_decap_8
XFILLER_15_507 VPWR VGND sg13g2_decap_8
XFILLER_27_345 VPWR VGND sg13g2_fill_1
XFILLER_27_378 VPWR VGND sg13g2_fill_1
XFILLER_42_326 VPWR VGND sg13g2_fill_2
XFILLER_24_33 VPWR VGND sg13g2_decap_4
XFILLER_11_724 VPWR VGND sg13g2_decap_8
XFILLER_23_595 VPWR VGND sg13g2_decap_8
XFILLER_10_267 VPWR VGND sg13g2_decap_8
XFILLER_46_1000 VPWR VGND sg13g2_decap_8
XFILLER_3_945 VPWR VGND sg13g2_decap_8
XFILLER_6_2 VPWR VGND sg13g2_fill_1
XFILLER_2_466 VPWR VGND sg13g2_decap_8
Xhold290 hold290/A VPWR VGND net673 sg13g2_dlygate4sd3_1
XFILLER_49_96 VPWR VGND sg13g2_decap_8
XFILLER_19_802 VPWR VGND sg13g2_decap_8
XFILLER_46_643 VPWR VGND sg13g2_decap_8
XFILLER_19_879 VPWR VGND sg13g2_decap_8
XFILLER_18_378 VPWR VGND sg13g2_fill_2
XFILLER_27_890 VPWR VGND sg13g2_decap_8
XFILLER_33_315 VPWR VGND sg13g2_decap_8
Xu_ppwm_u_ex__0930_ u_ppwm_u_ex__0960_/A VPWR u_ppwm_u_ex__0930_/Y VGND u_ppwm_u_ex__0889_/Y
+ u_ppwm_u_ex__0958_/B sg13g2_o21ai_1
XFILLER_42_860 VPWR VGND sg13g2_decap_8
XFILLER_14_562 VPWR VGND sg13g2_decap_8
Xu_ppwm_u_ex__0861_ u_ppwm_u_ex__1019_/A VPWR u_ppwm_u_ex__0861_/Y VGND net352 u_ppwm_u_ex__0859_/Y
+ sg13g2_o21ai_1
Xu_ppwm_u_ex__0792_ VGND VPWR u_ppwm_u_ex__0845_/C u_ppwm_u_ex__0860_/B u_ppwm_u_ex__0812_/B
+ u_ppwm/instr\[2\] sg13g2_a21oi_2
Xu_ppwm_u_pwm__246_ net206 VGND VPWR net553 hold169/A clknet_5_4__leaf_clk sg13g2_dfrbpq_1
Xu_ppwm_u_pwm__177_ net571 hold210/A u_ppwm_u_pwm__179_/B VPWR VGND sg13g2_nor2_1
XFILLER_6_750 VPWR VGND sg13g2_decap_8
XFILLER_5_271 VPWR VGND sg13g2_decap_4
XFILLER_49_481 VPWR VGND sg13g2_decap_8
XFILLER_25_816 VPWR VGND sg13g2_decap_8
XFILLER_37_665 VPWR VGND sg13g2_decap_8
XFILLER_20_510 VPWR VGND sg13g2_decap_8
XFILLER_32_392 VPWR VGND sg13g2_decap_4
XFILLER_33_893 VPWR VGND sg13g2_decap_8
Xu_ppwm_u_global_counter__177__73 VPWR VGND net73 sg13g2_tiehi
XFILLER_20_587 VPWR VGND sg13g2_decap_8
Xu_ppwm_u_mem__1119__113 VPWR VGND net113 sg13g2_tiehi
XFILLER_48_919 VPWR VGND sg13g2_decap_8
XFILLER_0_959 VPWR VGND sg13g2_decap_8
XFILLER_47_429 VPWR VGND sg13g2_decap_8
XFILLER_28_665 VPWR VGND sg13g2_decap_8
XFILLER_43_624 VPWR VGND sg13g2_decap_8
XFILLER_16_849 VPWR VGND sg13g2_decap_8
XFILLER_15_337 VPWR VGND sg13g2_fill_2
XFILLER_11_521 VPWR VGND sg13g2_decap_8
XFILLER_23_392 VPWR VGND sg13g2_fill_1
XFILLER_7_547 VPWR VGND sg13g2_decap_8
XFILLER_11_598 VPWR VGND sg13g2_decap_8
XFILLER_3_742 VPWR VGND sg13g2_decap_8
XFILLER_38_407 VPWR VGND sg13g2_fill_2
Xu_ppwm_u_ex__1060_ net495 VPWR u_ppwm_u_ex__1061_/B VGND net644 net342 sg13g2_o21ai_1
XFILLER_46_440 VPWR VGND sg13g2_decap_8
XFILLER_19_676 VPWR VGND sg13g2_decap_8
XFILLER_20_1014 VPWR VGND sg13g2_decap_8
XFILLER_47_996 VPWR VGND sg13g2_decap_8
XFILLER_34_668 VPWR VGND sg13g2_decap_8
XFILLER_15_871 VPWR VGND sg13g2_decap_8
XFILLER_21_307 VPWR VGND sg13g2_decap_4
XFILLER_21_318 VPWR VGND sg13g2_fill_1
XFILLER_22_819 VPWR VGND sg13g2_decap_8
Xu_ppwm_u_ex__0913_ VPWR VGND u_ppwm_u_ex__0821_/C u_ppwm_u_ex__0912_/Y u_ppwm_u_ex__0966_/A
+ u_ppwm_u_ex__0808_/Y u_ppwm_u_ex__0913_/Y u_ppwm_u_ex__0933_/B sg13g2_a221oi_1
Xu_ppwm_u_ex__0844_ u_ppwm_u_ex__0983_/A u_ppwm/instr\[0\] net374 u_ppwm_u_ex__0845_/C
+ VPWR VGND sg13g2_and3_2
XFILLER_30_885 VPWR VGND sg13g2_decap_8
Xu_ppwm_u_pwm__229_ u_ppwm_u_pwm__203_/B VPWR u_ppwm_u_pwm__230_/B VGND u_ppwm_u_pwm__200_/A
+ hold210/A sg13g2_o21ai_1
Xu_ppwm_u_ex__0775_ u_ppwm_u_ex__0774_/Y VPWR u_ppwm_u_ex__0776_/D VGND u_ppwm_u_ex__0765_/Y
+ u_ppwm_u_ex__0772_/Y sg13g2_o21ai_1
Xu_ppwm_u_mem__0987_ net488 VPWR u_ppwm_u_mem__0987_/Y VGND net337 net391 sg13g2_o21ai_1
XFILLER_44_0 VPWR VGND sg13g2_decap_8
Xclkbuf_5_25__f_clk clknet_4_12_0_clk clknet_5_25__leaf_clk VPWR VGND sg13g2_buf_8
Xu_ppwm_u_global_counter__178_ net65 VGND VPWR u_ppwm_u_global_counter__178_/D hold281/A
+ clknet_5_5__leaf_clk sg13g2_dfrbpq_2
XFILLER_38_952 VPWR VGND sg13g2_decap_8
XFILLER_25_613 VPWR VGND sg13g2_decap_8
XFILLER_13_819 VPWR VGND sg13g2_decap_8
XFILLER_21_841 VPWR VGND sg13g2_decap_8
XFILLER_33_690 VPWR VGND sg13g2_decap_8
XFILLER_21_34 VPWR VGND sg13g2_fill_2
XFILLER_0_756 VPWR VGND sg13g2_decap_8
XFILLER_48_716 VPWR VGND sg13g2_decap_8
XFILLER_29_941 VPWR VGND sg13g2_decap_8
Xu_ppwm_u_mem__1091__168 VPWR VGND net168 sg13g2_tiehi
XFILLER_44_922 VPWR VGND sg13g2_decap_8
XFILLER_28_462 VPWR VGND sg13g2_decap_8
XFILLER_16_646 VPWR VGND sg13g2_decap_8
XFILLER_44_999 VPWR VGND sg13g2_decap_8
XFILLER_43_498 VPWR VGND sg13g2_decap_8
XFILLER_31_649 VPWR VGND sg13g2_decap_8
Xu_ppwm_u_mem__0910_ VGND VPWR u_ppwm_u_mem__0677_/Y net401 u_ppwm_u_mem__1125_/D
+ u_ppwm_u_mem__0909_/Y sg13g2_a21oi_1
XFILLER_8_801 VPWR VGND sg13g2_decap_8
XFILLER_12_863 VPWR VGND sg13g2_decap_8
Xu_ppwm_u_mem__0841_ net486 VPWR u_ppwm_u_mem__0841_/Y VGND hold121/A net395 sg13g2_o21ai_1
XFILLER_8_878 VPWR VGND sg13g2_decap_8
XFILLER_11_395 VPWR VGND sg13g2_decap_8
Xu_ppwm_u_mem__0772_ u_ppwm_u_mem__0772_/Y hold84/A net469 VPWR VGND sg13g2_nand2b_1
XFILLER_39_738 VPWR VGND sg13g2_decap_8
Xu_ppwm_u_global_counter__101_ VGND VPWR net614 net428 hold232/A u_ppwm_u_global_counter__100_/Y
+ sg13g2_a21oi_1
XFILLER_16_4 VPWR VGND sg13g2_decap_8
Xu_ppwm_u_ex__1112_ VGND VPWR u_ppwm_u_ex__1106_/Y u_ppwm_u_ex__1110_/Y u_ppwm_u_ex__1141_/D
+ u_ppwm_u_ex__1111_/Y sg13g2_a21oi_1
XFILLER_38_237 VPWR VGND sg13g2_fill_2
Xu_ppwm_u_ex__1043_ VGND VPWR u_ppwm_u_ex__1065_/A u_ppwm_u_ex__1042_/B u_ppwm_u_ex__1044_/B
+ fanout349/A sg13g2_a21oi_1
XFILLER_47_793 VPWR VGND sg13g2_decap_8
XFILLER_35_933 VPWR VGND sg13g2_decap_8
Xu_ppwm_u_mem__1186_ net114 VGND VPWR u_ppwm_u_mem__1186_/D hold134/A clknet_5_22__leaf_clk
+ sg13g2_dfrbpq_1
XFILLER_22_616 VPWR VGND sg13g2_decap_8
XFILLER_30_682 VPWR VGND sg13g2_decap_8
Xu_ppwm_u_ex__0827_ u_ppwm_u_ex__0925_/B net361 net372 u_ppwm_u_ex__0827_/Y VPWR VGND
+ u_ppwm_u_ex__0827_/D sg13g2_nand4_1
Xu_ppwm_u_ex__0758_ u_ppwm_u_ex__0759_/C u_ppwm_u_ex__0604_/Y net437 u_ppwm_u_ex__0603_/Y
+ net436 VPWR VGND sg13g2_a22oi_1
Xu_ppwm_u_ex__0689_ net435 u_ppwm_u_ex__0689_/B u_ppwm_u_ex__0689_/C u_ppwm_u_ex__0689_/Y
+ VPWR VGND sg13g2_nor3_1
XFILLER_27_1009 VPWR VGND sg13g2_decap_8
XFILLER_29_215 VPWR VGND sg13g2_fill_2
XFILLER_26_900 VPWR VGND sg13g2_decap_8
XFILLER_13_616 VPWR VGND sg13g2_decap_8
XFILLER_26_977 VPWR VGND sg13g2_decap_8
XFILLER_41_958 VPWR VGND sg13g2_decap_8
XFILLER_40_413 VPWR VGND sg13g2_decap_8
XFILLER_25_487 VPWR VGND sg13g2_decap_8
XFILLER_40_457 VPWR VGND sg13g2_decap_8
XFILLER_32_11 VPWR VGND sg13g2_fill_1
XFILLER_5_804 VPWR VGND sg13g2_decap_8
XFILLER_10_1013 VPWR VGND sg13g2_decap_8
XFILLER_0_553 VPWR VGND sg13g2_decap_8
XFILLER_48_513 VPWR VGND sg13g2_decap_8
Xu_ppwm_u_mem__1040_ VGND VPWR u_ppwm_u_mem__0612_/Y net405 hold64/A u_ppwm_u_mem__1039_/Y
+ sg13g2_a21oi_1
XFILLER_17_944 VPWR VGND sg13g2_decap_8
XFILLER_16_454 VPWR VGND sg13g2_decap_8
XFILLER_32_914 VPWR VGND sg13g2_decap_8
XFILLER_44_796 VPWR VGND sg13g2_decap_8
XFILLER_43_284 VPWR VGND sg13g2_fill_1
XFILLER_12_660 VPWR VGND sg13g2_decap_8
Xhold108 hold108/A VPWR VGND net325 sg13g2_dlygate4sd3_1
XFILLER_8_675 VPWR VGND sg13g2_decap_8
Xu_ppwm_u_ex__0612_ u_ppwm_u_ex__0846_/A u_ppwm_u_ex__0773_/B u_ppwm_u_ex__0778_/C
+ u_ppwm_u_ex__0620_/B VPWR VGND sg13g2_nand3_1
Xu_ppwm_u_mem__0824_ net454 u_ppwm_u_mem__0824_/B u_ppwm_u_mem__0824_/Y VPWR VGND
+ sg13g2_nor2_1
Xhold119 hold119/A VPWR VGND net336 sg13g2_dlygate4sd3_1
Xu_ppwm_u_mem__0755_ u_ppwm_u_mem__0755_/Y hold79/A net470 VPWR VGND sg13g2_nand2_1
Xu_ppwm_u_mem__0686_ VPWR u_ppwm_u_mem__0686_/Y net293 VGND sg13g2_inv_1
Xu_ppwm_u_pwm__245__209 VPWR VGND net209 sg13g2_tiehi
XFILLER_39_535 VPWR VGND sg13g2_decap_8
XFILLER_27_708 VPWR VGND sg13g2_decap_8
XFILLER_47_590 VPWR VGND sg13g2_decap_8
XFILLER_19_292 VPWR VGND sg13g2_fill_1
Xu_ppwm_u_ex__1026_ VGND VPWR net439 net366 u_ppwm_u_ex__1026_/Y u_ppwm_u_ex__1018_/A
+ sg13g2_a21oi_1
XFILLER_35_730 VPWR VGND sg13g2_decap_8
XFILLER_23_903 VPWR VGND sg13g2_decap_8
Xu_ppwm_u_mem__1169_ net92 VGND VPWR u_ppwm_u_mem__1169_/D hold158/A clknet_5_12__leaf_clk
+ sg13g2_dfrbpq_1
XFILLER_40_1028 VPWR VGND sg13g2_fill_1
XFILLER_40_1017 VPWR VGND sg13g2_decap_8
XFILLER_26_774 VPWR VGND sg13g2_decap_8
XFILLER_27_88 VPWR VGND sg13g2_decap_4
XFILLER_14_947 VPWR VGND sg13g2_decap_8
XFILLER_25_273 VPWR VGND sg13g2_fill_1
XFILLER_43_54 VPWR VGND sg13g2_fill_2
XFILLER_41_755 VPWR VGND sg13g2_decap_8
XFILLER_43_87 VPWR VGND sg13g2_fill_2
XFILLER_40_265 VPWR VGND sg13g2_decap_8
XFILLER_22_980 VPWR VGND sg13g2_decap_8
XFILLER_40_298 VPWR VGND sg13g2_fill_2
XFILLER_5_601 VPWR VGND sg13g2_decap_8
XFILLER_49_1020 VPWR VGND sg13g2_decap_8
XFILLER_5_678 VPWR VGND sg13g2_decap_8
XFILLER_4_15 VPWR VGND sg13g2_decap_4
XFILLER_4_188 VPWR VGND sg13g2_fill_1
XFILLER_0_350 VPWR VGND sg13g2_decap_8
XFILLER_1_895 VPWR VGND sg13g2_decap_8
XFILLER_49_866 VPWR VGND sg13g2_decap_8
XFILLER_48_387 VPWR VGND sg13g2_decap_8
XFILLER_48_365 VPWR VGND sg13g2_decap_4
Xu_ppwm_u_mem__1138__193 VPWR VGND net193 sg13g2_tiehi
XFILLER_1_1000 VPWR VGND sg13g2_decap_8
XFILLER_17_741 VPWR VGND sg13g2_decap_8
Xu_ppwm_u_mem__1023_ net506 VPWR u_ppwm_u_mem__1023_/Y VGND net272 net417 sg13g2_o21ai_1
XFILLER_44_593 VPWR VGND sg13g2_decap_8
XFILLER_16_273 VPWR VGND sg13g2_fill_2
XFILLER_32_711 VPWR VGND sg13g2_decap_8
XFILLER_13_980 VPWR VGND sg13g2_decap_8
XFILLER_32_788 VPWR VGND sg13g2_decap_8
XFILLER_9_962 VPWR VGND sg13g2_decap_8
XFILLER_8_472 VPWR VGND sg13g2_decap_8
Xu_ppwm_u_mem__0807_ net465 hold183/A hold148/A hold35/A hold51/A net457 u_ppwm_u_mem__0808_/B
+ VPWR VGND sg13g2_mux4_1
Xu_ppwm_u_mem__0738_ net453 u_ppwm_u_mem__0738_/B u_ppwm_u_mem__0738_/Y VPWR VGND
+ sg13g2_nor2_1
Xfanout418 net419 net418 VPWR VGND sg13g2_buf_8
Xfanout429 fanout429/A net429 VPWR VGND sg13g2_buf_8
Xfanout407 net421 net407 VPWR VGND sg13g2_buf_8
Xu_ppwm_u_mem__0669_ VPWR u_ppwm_u_mem__0669_/Y net266 VGND sg13g2_inv_1
XFILLER_27_505 VPWR VGND sg13g2_decap_8
Xu_ppwm_u_ex__1009_ u_ppwm_u_ex__1010_/D u_ppwm_u_ex__1009_/A net342 VPWR VGND sg13g2_nand2_1
XFILLER_23_700 VPWR VGND sg13g2_decap_8
XFILLER_11_906 VPWR VGND sg13g2_decap_8
XFILLER_22_243 VPWR VGND sg13g2_decap_4
XFILLER_23_777 VPWR VGND sg13g2_decap_8
XFILLER_13_35 VPWR VGND sg13g2_fill_2
XFILLER_2_648 VPWR VGND sg13g2_decap_8
XFILLER_46_825 VPWR VGND sg13g2_decap_8
XFILLER_38_98 VPWR VGND sg13g2_fill_2
XFILLER_45_357 VPWR VGND sg13g2_fill_2
XFILLER_33_508 VPWR VGND sg13g2_decap_8
XFILLER_26_571 VPWR VGND sg13g2_decap_8
XFILLER_41_552 VPWR VGND sg13g2_decap_8
XFILLER_14_744 VPWR VGND sg13g2_decap_8
XFILLER_9_236 VPWR VGND sg13g2_fill_2
XFILLER_10_950 VPWR VGND sg13g2_decap_8
Xu_ppwm_u_pwm__193_ VGND VPWR u_ppwm_u_pwm__131_/Y net379 hold71/A u_ppwm_u_pwm__192_/Y
+ sg13g2_a21oi_1
XFILLER_6_932 VPWR VGND sg13g2_decap_8
XFILLER_48_7 VPWR VGND sg13g2_decap_8
XFILLER_5_475 VPWR VGND sg13g2_decap_8
Xclkbuf_5_6__f_clk clknet_4_3_0_clk clknet_5_6__leaf_clk VPWR VGND sg13g2_buf_8
XFILLER_1_692 VPWR VGND sg13g2_decap_8
XFILLER_23_1001 VPWR VGND sg13g2_decap_8
XFILLER_49_663 VPWR VGND sg13g2_decap_8
XFILLER_37_847 VPWR VGND sg13g2_decap_8
Xu_ppwm_u_mem__1006_ VGND VPWR u_ppwm_u_mem__0629_/Y net408 hold123/A u_ppwm_u_mem__1005_/Y
+ sg13g2_a21oi_1
XFILLER_32_585 VPWR VGND sg13g2_decap_8
Xu_ppwm_u_ex__1131__36 VPWR VGND net36 sg13g2_tiehi
XFILLER_20_769 VPWR VGND sg13g2_decap_8
XFILLER_28_847 VPWR VGND sg13g2_decap_8
XFILLER_43_806 VPWR VGND sg13g2_decap_8
XFILLER_42_316 VPWR VGND sg13g2_decap_8
XFILLER_11_703 VPWR VGND sg13g2_decap_8
XFILLER_23_574 VPWR VGND sg13g2_decap_8
XFILLER_7_729 VPWR VGND sg13g2_decap_8
Xu_ppwm_u_mem__1198__102 VPWR VGND net102 sg13g2_tiehi
XFILLER_3_924 VPWR VGND sg13g2_decap_8
Xhold280 hold280/A VPWR VGND net663 sg13g2_dlygate4sd3_1
XFILLER_2_445 VPWR VGND sg13g2_decap_8
Xhold291 hold291/A VPWR VGND net674 sg13g2_dlygate4sd3_1
XFILLER_49_75 VPWR VGND sg13g2_decap_8
XFILLER_46_622 VPWR VGND sg13g2_decap_8
XFILLER_19_858 VPWR VGND sg13g2_decap_8
Xu_ppwm_u_mem__1174__190 VPWR VGND net190 sg13g2_tiehi
XFILLER_46_699 VPWR VGND sg13g2_decap_8
XFILLER_14_541 VPWR VGND sg13g2_decap_8
XFILLER_41_382 VPWR VGND sg13g2_fill_1
Xu_ppwm_u_ex__0860_ u_ppwm_u_ex__1019_/A net367 u_ppwm_u_ex__0860_/B VPWR VGND sg13g2_nand2_1
Xu_ppwm_u_ex__0791_ net372 net450 u_ppwm_u_ex__0791_/X VPWR VGND sg13g2_xor2_1
Xu_ppwm_u_pwm__245_ net209 VGND VPWR net224 hold6/A clknet_5_4__leaf_clk sg13g2_dfrbpq_1
Xu_ppwm_u_pwm__176_ hold250/A hold229/A hold213/A hold205/A u_ppwm_u_pwm__179_/A VPWR
+ VGND sg13g2_nor4_1
XFILLER_5_250 VPWR VGND sg13g2_fill_2
XFILLER_49_460 VPWR VGND sg13g2_decap_8
XFILLER_37_644 VPWR VGND sg13g2_decap_8
XFILLER_36_187 VPWR VGND sg13g2_fill_1
XFILLER_24_338 VPWR VGND sg13g2_decap_4
XFILLER_33_872 VPWR VGND sg13g2_decap_8
Xu_ppwm_u_ex__0989_ VGND VPWR u_ppwm_u_ex__0980_/Y u_ppwm_u_ex__0987_/X u_ppwm_u_ex__1131_/D
+ u_ppwm_u_ex__0988_/Y sg13g2_a21oi_1
XFILLER_20_566 VPWR VGND sg13g2_decap_8
XFILLER_0_938 VPWR VGND sg13g2_decap_8
XFILLER_19_89 VPWR VGND sg13g2_fill_1
XFILLER_28_644 VPWR VGND sg13g2_decap_8
XFILLER_43_603 VPWR VGND sg13g2_decap_8
XFILLER_16_828 VPWR VGND sg13g2_decap_8
XFILLER_11_500 VPWR VGND sg13g2_decap_8
XFILLER_24_894 VPWR VGND sg13g2_decap_8
XFILLER_7_526 VPWR VGND sg13g2_decap_8
XFILLER_11_577 VPWR VGND sg13g2_decap_8
XFILLER_13_1022 VPWR VGND sg13g2_decap_8
XFILLER_3_721 VPWR VGND sg13g2_decap_8
XFILLER_3_798 VPWR VGND sg13g2_decap_8
XFILLER_47_975 VPWR VGND sg13g2_decap_8
XFILLER_19_655 VPWR VGND sg13g2_decap_8
XFILLER_46_496 VPWR VGND sg13g2_decap_8
XFILLER_34_647 VPWR VGND sg13g2_decap_8
XFILLER_15_850 VPWR VGND sg13g2_decap_8
XFILLER_33_157 VPWR VGND sg13g2_fill_1
Xu_ppwm_u_ex__0912_ u_ppwm_u_ex__0983_/A VPWR u_ppwm_u_ex__0912_/Y VGND u_ppwm_u_ex__0873_/A
+ u_ppwm_u_ex__0801_/B sg13g2_o21ai_1
Xu_ppwm_u_ex__0843_ u_ppwm_u_ex__0847_/B net365 net368 VPWR VGND sg13g2_nand2_1
XFILLER_30_864 VPWR VGND sg13g2_decap_8
Xu_ppwm_u_pwm__228_ VPWR VGND u_ppwm_u_pwm__215_/Y u_ppwm_u_pwm__227_/Y u_ppwm_u_pwm__226_/X
+ u_ppwm_u_pwm__227_/A u_ppwm_u_pwm__228_/Y u_ppwm_u_pwm__222_/D sg13g2_a221oi_1
Xu_ppwm_u_ex__0774_ VGND VPWR u_ppwm_u_ex__0772_/A u_ppwm_u_ex__0771_/C u_ppwm_u_ex__0774_/Y
+ u_ppwm_u_ex__0773_/Y sg13g2_a21oi_1
Xu_ppwm_u_mem__0986_ VGND VPWR u_ppwm_u_mem__0639_/Y net390 hold36/A u_ppwm_u_mem__0985_/Y
+ sg13g2_a21oi_1
Xu_ppwm_u_pwm__159_ VGND VPWR hold250/A u_ppwm_u_pwm__156_/C hold201/A net583 sg13g2_a21oi_1
XFILLER_37_0 VPWR VGND sg13g2_decap_8
XFILLER_38_931 VPWR VGND sg13g2_decap_8
Xu_ppwm_u_global_counter__177_ net73 VGND VPWR net638 hold254/A clknet_5_4__leaf_clk
+ sg13g2_dfrbpq_2
XFILLER_25_669 VPWR VGND sg13g2_decap_8
XFILLER_40_639 VPWR VGND sg13g2_decap_8
XFILLER_21_820 VPWR VGND sg13g2_decap_8
XFILLER_21_897 VPWR VGND sg13g2_decap_8
XFILLER_4_529 VPWR VGND sg13g2_decap_8
XFILLER_0_735 VPWR VGND sg13g2_decap_8
Xu_ppwm_u_mem__1195__149 VPWR VGND net149 sg13g2_tiehi
XFILLER_29_920 VPWR VGND sg13g2_decap_8
XFILLER_46_65 VPWR VGND sg13g2_fill_2
XFILLER_44_901 VPWR VGND sg13g2_decap_8
XFILLER_43_400 VPWR VGND sg13g2_fill_2
XFILLER_16_625 VPWR VGND sg13g2_decap_8
XFILLER_29_997 VPWR VGND sg13g2_decap_8
XFILLER_44_978 VPWR VGND sg13g2_decap_8
XFILLER_43_477 VPWR VGND sg13g2_decap_8
XFILLER_15_168 VPWR VGND sg13g2_decap_4
XFILLER_24_691 VPWR VGND sg13g2_decap_8
XFILLER_31_628 VPWR VGND sg13g2_decap_8
XFILLER_12_842 VPWR VGND sg13g2_decap_8
XFILLER_30_149 VPWR VGND sg13g2_fill_2
Xu_ppwm_u_mem__0840_ VGND VPWR u_ppwm_u_mem__0712_/Y net394 hold60/A u_ppwm_u_mem__0839_/Y
+ sg13g2_a21oi_1
XFILLER_11_374 VPWR VGND sg13g2_fill_1
XFILLER_8_857 VPWR VGND sg13g2_decap_8
Xclkbuf_5_31__f_clk clknet_4_15_0_clk clknet_5_31__leaf_clk VPWR VGND sg13g2_buf_8
XFILLER_7_389 VPWR VGND sg13g2_fill_1
Xu_ppwm_u_mem__0771_ u_ppwm_u_mem__0771_/Y hold114/A net469 VPWR VGND sg13g2_nand2_1
XFILLER_3_595 VPWR VGND sg13g2_decap_8
XFILLER_39_717 VPWR VGND sg13g2_decap_8
Xu_ppwm_u_global_counter__100_ net495 VPWR u_ppwm_u_global_counter__100_/Y VGND net614
+ net428 sg13g2_o21ai_1
Xu_ppwm_u_ex__1111_ net481 VPWR u_ppwm_u_ex__1111_/Y VGND net430 net341 sg13g2_o21ai_1
Xu_ppwm_u_ex__1042_ VGND VPWR u_ppwm_u_ex__1052_/B u_ppwm_u_ex__1042_/B u_ppwm_u_ex__1065_/A
+ sg13g2_or2_1
XFILLER_47_772 VPWR VGND sg13g2_decap_8
XFILLER_35_912 VPWR VGND sg13g2_decap_8
Xu_ppwm_u_mem__1185_ net122 VGND VPWR net259 hold41/A clknet_5_28__leaf_clk sg13g2_dfrbpq_1
XFILLER_35_989 VPWR VGND sg13g2_decap_8
XFILLER_21_127 VPWR VGND sg13g2_fill_2
XFILLER_30_661 VPWR VGND sg13g2_decap_8
Xu_ppwm_u_ex__0826_ VGND VPWR net370 u_ppwm_u_ex__0808_/Y u_ppwm_u_ex__0872_/A u_ppwm_u_ex__0825_/Y
+ sg13g2_a21oi_1
Xu_ppwm_u_ex__0757_ u_ppwm_u_ex__0760_/A net427 net436 VPWR VGND sg13g2_nand2b_1
Xu_ppwm_u_mem__0969_ net484 VPWR u_ppwm_u_mem__0969_/Y VGND net531 net393 sg13g2_o21ai_1
XFILLER_7_890 VPWR VGND sg13g2_decap_8
Xu_ppwm_u_ex__0688_ u_ppwm_u_ex__0687_/Y VPWR u_ppwm_u_ex__0688_/Y VGND u_ppwm_u_ex__0680_/Y
+ u_ppwm_u_ex__0684_/Y sg13g2_o21ai_1
XFILLER_26_956 VPWR VGND sg13g2_decap_8
XFILLER_25_466 VPWR VGND sg13g2_decap_8
XFILLER_41_937 VPWR VGND sg13g2_decap_8
XFILLER_21_694 VPWR VGND sg13g2_decap_8
XFILLER_0_532 VPWR VGND sg13g2_decap_8
XFILLER_48_569 VPWR VGND sg13g2_decap_8
XFILLER_17_923 VPWR VGND sg13g2_decap_8
XFILLER_29_794 VPWR VGND sg13g2_decap_8
XFILLER_44_775 VPWR VGND sg13g2_decap_8
XFILLER_43_230 VPWR VGND sg13g2_fill_2
XFILLER_16_499 VPWR VGND sg13g2_decap_8
XFILLER_8_654 VPWR VGND sg13g2_decap_8
XFILLER_7_142 VPWR VGND sg13g2_fill_1
Xu_ppwm_u_ex__0611_ net374 net376 u_ppwm_u_ex__0773_/B VPWR VGND sg13g2_nor2b_2
Xu_ppwm_u_mem__0823_ net465 hold20/A hold102/A hold185/A hold127/A net457 u_ppwm_u_mem__0824_/B
+ VPWR VGND sg13g2_mux4_1
Xhold109 hold109/A VPWR VGND net326 sg13g2_dlygate4sd3_1
Xu_ppwm_u_mem__0754_ net460 VPWR u_ppwm_u_mem__0754_/Y VGND hold153/A net466 sg13g2_o21ai_1
Xu_ppwm_u_mem__0685_ VPWR u_ppwm_u_mem__0685_/Y net535 VGND sg13g2_inv_1
XFILLER_4_893 VPWR VGND sg13g2_decap_8
XFILLER_3_370 VPWR VGND sg13g2_fill_2
XFILLER_3_392 VPWR VGND sg13g2_decap_8
XFILLER_39_514 VPWR VGND sg13g2_decap_8
XFILLER_26_208 VPWR VGND sg13g2_fill_1
Xu_ppwm_u_ex__1025_ VGND VPWR u_ppwm_u_ex__0863_/B u_ppwm_u_ex__1023_/Y hold304/A
+ u_ppwm_u_ex__1024_/Y sg13g2_a21oi_1
Xu_ppwm_u_mem__1168_ net96 VGND VPWR net250 hold32/A clknet_5_9__leaf_clk sg13g2_dfrbpq_1
XFILLER_35_786 VPWR VGND sg13g2_decap_8
Xu_ppwm_u_mem__1099_ net152 VGND VPWR net330 hold112/A clknet_5_11__leaf_clk sg13g2_dfrbpq_1
XFILLER_23_959 VPWR VGND sg13g2_decap_8
XFILLER_22_469 VPWR VGND sg13g2_decap_8
XFILLER_31_992 VPWR VGND sg13g2_decap_8
Xu_ppwm_u_ex__0809_ VGND VPWR net361 u_ppwm_u_ex__0808_/Y u_ppwm_u_ex__0809_/Y u_ppwm_u_ex__0806_/Y
+ sg13g2_a21oi_1
XFILLER_26_753 VPWR VGND sg13g2_decap_8
XFILLER_41_734 VPWR VGND sg13g2_decap_8
XFILLER_14_926 VPWR VGND sg13g2_decap_8
XFILLER_40_222 VPWR VGND sg13g2_fill_1
XFILLER_40_277 VPWR VGND sg13g2_decap_4
XFILLER_9_418 VPWR VGND sg13g2_fill_2
XFILLER_21_491 VPWR VGND sg13g2_decap_8
XFILLER_5_657 VPWR VGND sg13g2_decap_8
XFILLER_4_101 VPWR VGND sg13g2_decap_8
XFILLER_1_874 VPWR VGND sg13g2_decap_8
XFILLER_49_845 VPWR VGND sg13g2_decap_8
XFILLER_17_720 VPWR VGND sg13g2_decap_8
XFILLER_29_591 VPWR VGND sg13g2_decap_8
Xu_ppwm_u_mem__1022_ VGND VPWR u_ppwm_u_mem__0621_/Y net409 hold80/A u_ppwm_u_mem__1021_/Y
+ sg13g2_a21oi_1
XFILLER_44_572 VPWR VGND sg13g2_decap_8
XFILLER_17_797 VPWR VGND sg13g2_decap_8
XFILLER_31_233 VPWR VGND sg13g2_decap_8
XFILLER_32_767 VPWR VGND sg13g2_decap_8
XFILLER_31_277 VPWR VGND sg13g2_decap_8
XFILLER_9_941 VPWR VGND sg13g2_decap_8
Xu_ppwm_u_mem__1106__138 VPWR VGND net138 sg13g2_tiehi
Xu_ppwm_u_mem__0806_ net453 VPWR u_ppwm_u_mem__0806_/Y VGND u_ppwm_u_mem__0801_/Y
+ u_ppwm_u_mem__0802_/Y sg13g2_o21ai_1
Xu_ppwm_u_mem__0737_ net465 hold26/A hold65/A hold81/A hold39/A net457 u_ppwm_u_mem__0738_/B
+ VPWR VGND sg13g2_mux4_1
Xu_ppwm_u_mem__0668_ VPWR u_ppwm_u_mem__0668_/Y net530 VGND sg13g2_inv_1
Xfanout419 net420 net419 VPWR VGND sg13g2_buf_2
XFILLER_4_690 VPWR VGND sg13g2_decap_8
Xfanout408 net410 net408 VPWR VGND sg13g2_buf_8
Xu_ppwm_u_ex__1008_ VGND VPWR u_ppwm_u_ex__0996_/Y u_ppwm_u_ex__1006_/Y u_ppwm_u_ex__1010_/C
+ u_ppwm_u_ex__1007_/Y sg13g2_a21oi_1
XFILLER_35_583 VPWR VGND sg13g2_decap_8
XFILLER_22_222 VPWR VGND sg13g2_decap_8
XFILLER_23_756 VPWR VGND sg13g2_decap_8
XFILLER_2_627 VPWR VGND sg13g2_decap_8
XFILLER_1_148 VPWR VGND sg13g2_fill_1
XFILLER_1_137 VPWR VGND sg13g2_decap_8
XFILLER_1_159 VPWR VGND sg13g2_decap_8
XFILLER_46_804 VPWR VGND sg13g2_decap_8
XFILLER_26_550 VPWR VGND sg13g2_decap_8
XFILLER_14_723 VPWR VGND sg13g2_decap_8
XFILLER_41_531 VPWR VGND sg13g2_decap_8
XFILLER_13_211 VPWR VGND sg13g2_decap_8
XFILLER_9_215 VPWR VGND sg13g2_fill_1
XFILLER_13_299 VPWR VGND sg13g2_fill_1
Xu_ppwm_u_pwm__192_ net479 VPWR u_ppwm_u_pwm__192_/Y VGND net442 net378 sg13g2_o21ai_1
XFILLER_6_911 VPWR VGND sg13g2_decap_8
XFILLER_6_988 VPWR VGND sg13g2_decap_8
XFILLER_5_454 VPWR VGND sg13g2_decap_8
XFILLER_1_671 VPWR VGND sg13g2_decap_8
XFILLER_49_642 VPWR VGND sg13g2_decap_8
XFILLER_0_192 VPWR VGND sg13g2_decap_8
XFILLER_37_826 VPWR VGND sg13g2_decap_8
XFILLER_24_509 VPWR VGND sg13g2_decap_8
Xu_ppwm_u_mem__1005_ net504 VPWR u_ppwm_u_mem__1005_/Y VGND hold168/A net409 sg13g2_o21ai_1
XFILLER_17_594 VPWR VGND sg13g2_decap_8
XFILLER_32_564 VPWR VGND sg13g2_decap_8
XFILLER_20_748 VPWR VGND sg13g2_decap_8
XFILLER_5_81 VPWR VGND sg13g2_fill_2
XFILLER_8_1018 VPWR VGND sg13g2_decap_8
XFILLER_28_826 VPWR VGND sg13g2_decap_8
Xu_ppwm_u_mem__1127__97 VPWR VGND net97 sg13g2_tiehi
XFILLER_27_369 VPWR VGND sg13g2_decap_8
XFILLER_42_328 VPWR VGND sg13g2_fill_1
XFILLER_23_553 VPWR VGND sg13g2_decap_8
XFILLER_10_214 VPWR VGND sg13g2_fill_2
XFILLER_7_708 VPWR VGND sg13g2_decap_8
XFILLER_11_759 VPWR VGND sg13g2_decap_8
XFILLER_3_903 VPWR VGND sg13g2_decap_8
XFILLER_49_21 VPWR VGND sg13g2_decap_8
Xhold270 hold270/A VPWR VGND net653 sg13g2_dlygate4sd3_1
XFILLER_2_424 VPWR VGND sg13g2_decap_8
Xhold281 hold281/A VPWR VGND net664 sg13g2_dlygate4sd3_1
Xhold292 hold292/A VPWR VGND net675 sg13g2_dlygate4sd3_1
XFILLER_46_601 VPWR VGND sg13g2_decap_8
XFILLER_1_28 VPWR VGND sg13g2_decap_8
XFILLER_19_837 VPWR VGND sg13g2_decap_8
XFILLER_18_347 VPWR VGND sg13g2_fill_2
XFILLER_46_678 VPWR VGND sg13g2_decap_8
XFILLER_34_829 VPWR VGND sg13g2_decap_8
XFILLER_14_520 VPWR VGND sg13g2_decap_8
XFILLER_41_350 VPWR VGND sg13g2_fill_2
XFILLER_42_895 VPWR VGND sg13g2_decap_8
XFILLER_14_597 VPWR VGND sg13g2_decap_8
Xu_ppwm_u_ex__0790_ u_ppwm_u_ex__0790_/Y net450 net372 VPWR VGND sg13g2_nand2_1
Xu_ppwm_u_pwm__244_ net211 VGND VPWR u_ppwm_u_pwm__244_/D hold188/A clknet_5_0__leaf_clk
+ sg13g2_dfrbpq_1
Xu_ppwm_u_pwm__175_ u_ppwm_u_pwm__175_/A u_ppwm_u_pwm__175_/B u_ppwm_u_pwm__244_/D
+ VPWR VGND sg13g2_nor2_1
XFILLER_6_785 VPWR VGND sg13g2_decap_8
XFILLER_2_991 VPWR VGND sg13g2_decap_8
XFILLER_37_623 VPWR VGND sg13g2_decap_8
XFILLER_33_851 VPWR VGND sg13g2_decap_8
Xu_ppwm_u_ex__0988_ net482 VPWR u_ppwm_u_ex__0988_/Y VGND net654 net344 sg13g2_o21ai_1
XFILLER_20_545 VPWR VGND sg13g2_decap_8
XFILLER_0_917 VPWR VGND sg13g2_decap_8
XFILLER_28_623 VPWR VGND sg13g2_decap_8
XFILLER_16_807 VPWR VGND sg13g2_decap_8
XFILLER_27_122 VPWR VGND sg13g2_fill_1
XFILLER_43_659 VPWR VGND sg13g2_decap_8
XFILLER_24_873 VPWR VGND sg13g2_decap_8
XFILLER_7_505 VPWR VGND sg13g2_decap_8
XFILLER_11_556 VPWR VGND sg13g2_decap_8
XFILLER_13_1001 VPWR VGND sg13g2_decap_8
XFILLER_3_700 VPWR VGND sg13g2_decap_8
XFILLER_3_777 VPWR VGND sg13g2_decap_8
XFILLER_2_243 VPWR VGND sg13g2_fill_1
XFILLER_2_276 VPWR VGND sg13g2_fill_2
XFILLER_47_954 VPWR VGND sg13g2_decap_8
XFILLER_19_634 VPWR VGND sg13g2_decap_8
XFILLER_46_475 VPWR VGND sg13g2_decap_8
XFILLER_34_626 VPWR VGND sg13g2_decap_8
XFILLER_42_692 VPWR VGND sg13g2_decap_8
Xu_ppwm_u_ex__0911_ u_ppwm_u_ex__0910_/Y VPWR u_ppwm_u_ex__0922_/B VGND u_ppwm_u_ex__0908_/Y
+ u_ppwm_u_ex__0929_/B sg13g2_o21ai_1
Xu_ppwm_u_ex__0842_ net365 net368 u_ppwm_u_ex__0933_/B VPWR VGND sg13g2_and2_1
XFILLER_30_843 VPWR VGND sg13g2_decap_8
Xu_ppwm_u_mem__0985_ net487 VPWR u_ppwm_u_mem__0985_/Y VGND hold185/A net389 sg13g2_o21ai_1
Xu_ppwm_u_pwm__227_ u_ppwm_u_pwm__227_/A u_ppwm_u_pwm__227_/B u_ppwm_u_pwm__227_/C
+ u_ppwm_u_pwm__227_/D u_ppwm_u_pwm__227_/Y VPWR VGND sg13g2_nor4_1
Xu_ppwm_u_ex__0773_ u_ppwm_u_ex__0773_/B u_ppwm_u_ex__0773_/C net360 u_ppwm_u_ex__0773_/Y
+ VPWR VGND sg13g2_nand3_1
XFILLER_6_582 VPWR VGND sg13g2_decap_8
Xu_ppwm_u_pwm__158_ VGND VPWR u_ppwm_u_pwm__160_/B u_ppwm_u_pwm__160_/C hold251/A
+ u_ppwm_u_pwm__157_/Y sg13g2_a21oi_1
XFILLER_38_910 VPWR VGND sg13g2_decap_8
Xu_ppwm_u_global_counter__176_ net61 VGND VPWR net640 hold256/A clknet_5_5__leaf_clk
+ sg13g2_dfrbpq_2
XFILLER_38_987 VPWR VGND sg13g2_decap_8
XFILLER_25_648 VPWR VGND sg13g2_decap_8
XFILLER_37_497 VPWR VGND sg13g2_decap_8
XFILLER_40_618 VPWR VGND sg13g2_decap_8
XFILLER_36_1012 VPWR VGND sg13g2_decap_8
XFILLER_20_342 VPWR VGND sg13g2_fill_1
XFILLER_21_876 VPWR VGND sg13g2_decap_8
Xu_ppwm_u_global_counter__165__56 VPWR VGND net56 sg13g2_tiehi
XFILLER_21_36 VPWR VGND sg13g2_fill_1
XFILLER_4_508 VPWR VGND sg13g2_decap_8
XFILLER_0_714 VPWR VGND sg13g2_decap_8
XFILLER_43_1027 VPWR VGND sg13g2_fill_2
XFILLER_43_1016 VPWR VGND sg13g2_decap_8
XFILLER_16_604 VPWR VGND sg13g2_decap_8
XFILLER_29_976 VPWR VGND sg13g2_decap_8
XFILLER_44_957 VPWR VGND sg13g2_decap_8
XFILLER_28_497 VPWR VGND sg13g2_decap_8
XFILLER_31_607 VPWR VGND sg13g2_decap_8
XFILLER_12_821 VPWR VGND sg13g2_decap_8
XFILLER_24_670 VPWR VGND sg13g2_decap_8
XFILLER_23_191 VPWR VGND sg13g2_decap_4
XFILLER_8_836 VPWR VGND sg13g2_decap_8
XFILLER_7_313 VPWR VGND sg13g2_fill_1
XFILLER_12_898 VPWR VGND sg13g2_decap_8
Xu_ppwm_u_mem__0770_ net460 VPWR u_ppwm_u_mem__0770_/Y VGND hold163/A net471 sg13g2_o21ai_1
XFILLER_3_574 VPWR VGND sg13g2_decap_8
Xclkbuf_4_9_0_clk clknet_0_clk clknet_4_9_0_clk VPWR VGND sg13g2_buf_8
Xu_ppwm_u_ex__1110_ u_ppwm_u_ex__1110_/A u_ppwm_u_ex__0987_/B u_ppwm_u_ex__1110_/Y
+ VPWR VGND sg13g2_nor2b_1
XFILLER_47_751 VPWR VGND sg13g2_decap_8
Xu_ppwm_u_ex__1041_ VGND VPWR u_ppwm_u_ex__1039_/Y u_ppwm_u_ex__1042_/B u_ppwm_u_ex__1040_/Y
+ u_ppwm_u_ex__1016_/A sg13g2_a21oi_2
Xu_ppwm_u_mem__1184_ net129 VGND VPWR u_ppwm_u_mem__1184_/D hold43/A clknet_5_28__leaf_clk
+ sg13g2_dfrbpq_1
XFILLER_35_968 VPWR VGND sg13g2_decap_8
XFILLER_30_640 VPWR VGND sg13g2_decap_8
Xu_ppwm_u_mem__1148__174 VPWR VGND net174 sg13g2_tiehi
Xu_ppwm_u_ex__0825_ net370 u_ppwm_u_ex__0827_/D u_ppwm_u_ex__0825_/Y VPWR VGND sg13g2_nor2_1
Xu_ppwm_u_ex__0756_ u_ppwm_u_ex__0759_/A net434 net426 VPWR VGND sg13g2_nand2b_1
Xu_ppwm_u_mem__0968_ VGND VPWR u_ppwm_u_mem__0648_/Y net383 u_ppwm_u_mem__1154_/D
+ u_ppwm_u_mem__0967_/Y sg13g2_a21oi_1
Xu_ppwm_u_mem__0899_ net501 VPWR u_ppwm_u_mem__0899_/Y VGND net234 net413 sg13g2_o21ai_1
Xu_ppwm_u_ex__0687_ VPWR VGND net437 u_ppwm_u_ex__0685_/X u_ppwm_u_ex__0658_/A hold261/A
+ u_ppwm_u_ex__0687_/Y u_ppwm_u_ex__0715_/A sg13g2_a221oi_1
Xu_ppwm_u_mem__1169__92 VPWR VGND net92 sg13g2_tiehi
XFILLER_37_250 VPWR VGND sg13g2_fill_2
XFILLER_38_784 VPWR VGND sg13g2_decap_8
Xu_ppwm_u_mem__1090__170 VPWR VGND net170 sg13g2_tiehi
Xu_ppwm_u_global_counter__159_ net429 net643 u_ppwm_u_global_counter__179_/D VPWR
+ VGND sg13g2_nor2_1
XFILLER_16_25 VPWR VGND sg13g2_decap_8
XFILLER_26_935 VPWR VGND sg13g2_decap_8
XFILLER_41_916 VPWR VGND sg13g2_decap_8
XFILLER_25_445 VPWR VGND sg13g2_decap_8
XFILLER_34_990 VPWR VGND sg13g2_decap_8
XFILLER_21_673 VPWR VGND sg13g2_decap_8
XFILLER_5_839 VPWR VGND sg13g2_decap_8
XFILLER_4_338 VPWR VGND sg13g2_fill_2
XFILLER_0_511 VPWR VGND sg13g2_decap_8
XFILLER_0_588 VPWR VGND sg13g2_decap_8
XFILLER_48_548 VPWR VGND sg13g2_decap_8
XFILLER_17_902 VPWR VGND sg13g2_decap_8
XFILLER_29_773 VPWR VGND sg13g2_decap_8
XFILLER_44_754 VPWR VGND sg13g2_decap_8
XFILLER_17_979 VPWR VGND sg13g2_decap_8
XFILLER_43_264 VPWR VGND sg13g2_fill_2
XFILLER_32_949 VPWR VGND sg13g2_decap_8
XFILLER_40_982 VPWR VGND sg13g2_decap_8
XFILLER_8_633 VPWR VGND sg13g2_decap_8
XFILLER_11_183 VPWR VGND sg13g2_decap_4
XFILLER_12_695 VPWR VGND sg13g2_decap_8
Xu_ppwm_u_ex__0610_ u_ppwm_u_ex__0873_/A u_ppwm_u_ex__0925_/B net360 VPWR VGND sg13g2_nand2_2
Xu_ppwm_u_mem__0822_ net453 VPWR u_ppwm_u_mem__0822_/Y VGND u_ppwm_u_mem__0817_/Y
+ u_ppwm_u_mem__0818_/Y sg13g2_o21ai_1
Xu_ppwm_u_mem__0753_ hold30/A net466 u_ppwm_u_mem__0753_/Y VPWR VGND sg13g2_nor2b_1
Xu_ppwm_u_mem__0684_ VPWR u_ppwm_u_mem__0684_/Y net254 VGND sg13g2_inv_1
XFILLER_4_872 VPWR VGND sg13g2_decap_8
XFILLER_21_4 VPWR VGND sg13g2_fill_2
Xu_ppwm_u_ex__1024_ net495 VPWR u_ppwm_u_ex__1024_/Y VGND net439 net342 sg13g2_o21ai_1
Xu_ppwm_u_mem__1167_ net100 VGND VPWR u_ppwm_u_mem__1167_/D hold106/A clknet_5_9__leaf_clk
+ sg13g2_dfrbpq_1
XFILLER_35_765 VPWR VGND sg13g2_decap_8
Xu_ppwm_u_mem__1098_ net154 VGND VPWR u_ppwm_u_mem__1098_/D hold140/A clknet_5_11__leaf_clk
+ sg13g2_dfrbpq_1
XFILLER_23_938 VPWR VGND sg13g2_decap_8
XFILLER_22_459 VPWR VGND sg13g2_fill_1
XFILLER_31_971 VPWR VGND sg13g2_decap_8
XFILLER_33_1026 VPWR VGND sg13g2_fill_2
Xu_ppwm_u_ex__0808_ VGND VPWR net448 u_ppwm_u_ex__0896_/B u_ppwm_u_ex__0808_/Y u_ppwm_u_ex__0807_/X
+ sg13g2_a21oi_1
Xu_ppwm_u_ex__0739_ u_ppwm_u_ex__0742_/A net432 hold256/A VPWR VGND sg13g2_xnor2_1
XFILLER_2_809 VPWR VGND sg13g2_decap_8
XFILLER_45_529 VPWR VGND sg13g2_decap_8
XFILLER_26_732 VPWR VGND sg13g2_decap_8
XFILLER_38_581 VPWR VGND sg13g2_decap_8
XFILLER_14_905 VPWR VGND sg13g2_decap_8
XFILLER_41_713 VPWR VGND sg13g2_decap_8
XFILLER_43_34 VPWR VGND sg13g2_fill_2
XFILLER_5_636 VPWR VGND sg13g2_decap_8
XFILLER_4_179 VPWR VGND sg13g2_decap_8
XFILLER_1_853 VPWR VGND sg13g2_decap_8
Xu_ppwm_u_pwm__244__211 VPWR VGND net211 sg13g2_tiehi
XFILLER_49_824 VPWR VGND sg13g2_decap_8
XFILLER_0_385 VPWR VGND sg13g2_decap_8
XFILLER_48_356 VPWR VGND sg13g2_fill_2
XFILLER_29_570 VPWR VGND sg13g2_decap_8
XFILLER_36_529 VPWR VGND sg13g2_decap_8
XFILLER_44_551 VPWR VGND sg13g2_decap_8
XFILLER_16_231 VPWR VGND sg13g2_fill_1
Xu_ppwm_u_mem__1021_ net504 VPWR u_ppwm_u_mem__1021_/Y VGND hold114/A net417 sg13g2_o21ai_1
XFILLER_16_253 VPWR VGND sg13g2_decap_8
XFILLER_17_776 VPWR VGND sg13g2_decap_8
XFILLER_32_746 VPWR VGND sg13g2_decap_8
XFILLER_9_920 VPWR VGND sg13g2_decap_8
XFILLER_9_997 VPWR VGND sg13g2_decap_8
XFILLER_12_492 VPWR VGND sg13g2_decap_8
Xu_ppwm_u_mem__0805_ VGND VPWR u_ppwm_u_mem__0803_/Y u_ppwm_u_mem__0804_/Y u_ppwm_u_mem__0805_/Y
+ net459 sg13g2_a21oi_1
Xu_ppwm_u_mem__0736_ u_ppwm_u_mem__0735_/Y VPWR u_ppwm/instr\[0\] VGND u_ppwm_u_mem__0722_/Y
+ u_ppwm_u_mem__0729_/Y sg13g2_o21ai_1
Xu_ppwm_u_mem__0667_ VPWR u_ppwm_u_mem__0667_/Y net324 VGND sg13g2_inv_1
Xfanout409 net410 net409 VPWR VGND sg13g2_buf_1
XFILLER_39_312 VPWR VGND sg13g2_decap_4
XFILLER_39_367 VPWR VGND sg13g2_decap_8
Xu_ppwm_u_mem__1152__159 VPWR VGND net159 sg13g2_tiehi
Xu_ppwm_u_ex__1007_ fanout350/A VPWR u_ppwm_u_ex__1007_/Y VGND u_ppwm_u_ex__0996_/Y
+ u_ppwm_u_ex__1006_/Y sg13g2_o21ai_1
XFILLER_35_562 VPWR VGND sg13g2_decap_8
XFILLER_23_735 VPWR VGND sg13g2_decap_8
XFILLER_2_606 VPWR VGND sg13g2_decap_8
XFILLER_1_116 VPWR VGND sg13g2_decap_8
XFILLER_18_529 VPWR VGND sg13g2_decap_8
XFILLER_14_702 VPWR VGND sg13g2_decap_8
XFILLER_41_510 VPWR VGND sg13g2_decap_8
XFILLER_13_245 VPWR VGND sg13g2_decap_4
XFILLER_13_256 VPWR VGND sg13g2_decap_8
XFILLER_14_779 VPWR VGND sg13g2_decap_8
XFILLER_16_1010 VPWR VGND sg13g2_decap_8
XFILLER_41_587 VPWR VGND sg13g2_decap_8
Xu_ppwm_u_pwm__191_ VGND VPWR u_ppwm_u_pwm__132_/Y net379 hold47/A u_ppwm_u_pwm__190_/Y
+ sg13g2_a21oi_1
XFILLER_10_985 VPWR VGND sg13g2_decap_8
XFILLER_6_967 VPWR VGND sg13g2_decap_8
XFILLER_5_433 VPWR VGND sg13g2_decap_8
XFILLER_1_650 VPWR VGND sg13g2_decap_8
XFILLER_49_621 VPWR VGND sg13g2_decap_8
XFILLER_0_171 VPWR VGND sg13g2_decap_8
XFILLER_37_805 VPWR VGND sg13g2_decap_8
XFILLER_49_698 VPWR VGND sg13g2_decap_8
XFILLER_17_573 VPWR VGND sg13g2_decap_8
Xu_ppwm_u_mem__1004_ VGND VPWR u_ppwm_u_mem__0630_/Y net410 u_ppwm_u_mem__1172_/D
+ u_ppwm_u_mem__1003_/Y sg13g2_a21oi_1
XFILLER_45_893 VPWR VGND sg13g2_decap_8
XFILLER_32_543 VPWR VGND sg13g2_decap_8
XFILLER_20_727 VPWR VGND sg13g2_decap_8
XFILLER_9_794 VPWR VGND sg13g2_decap_8
XFILLER_30_1018 VPWR VGND sg13g2_decap_8
Xu_ppwm_u_mem__0719_ u_ppwm_u_mem__1080_/A net518 net631 VPWR VGND sg13g2_nand2_1
XFILLER_5_93 VPWR VGND sg13g2_fill_2
XFILLER_28_805 VPWR VGND sg13g2_decap_8
XFILLER_23_532 VPWR VGND sg13g2_decap_8
XFILLER_36_893 VPWR VGND sg13g2_decap_8
XFILLER_11_738 VPWR VGND sg13g2_decap_8
XFILLER_40_35 VPWR VGND sg13g2_fill_2
XFILLER_2_403 VPWR VGND sg13g2_decap_8
XFILLER_46_1014 VPWR VGND sg13g2_decap_8
Xhold260 hold260/A VPWR VGND net643 sg13g2_dlygate4sd3_1
XFILLER_3_959 VPWR VGND sg13g2_decap_8
Xhold271 hold271/A VPWR VGND net654 sg13g2_dlygate4sd3_1
Xhold282 hold282/A VPWR VGND net665 sg13g2_dlygate4sd3_1
Xhold293 hold293/A VPWR VGND net676 sg13g2_dlygate4sd3_1
XFILLER_19_816 VPWR VGND sg13g2_decap_8
XFILLER_46_657 VPWR VGND sg13g2_decap_8
XFILLER_18_337 VPWR VGND sg13g2_fill_1
XFILLER_34_808 VPWR VGND sg13g2_decap_8
XFILLER_42_874 VPWR VGND sg13g2_decap_8
XFILLER_14_576 VPWR VGND sg13g2_decap_8
Xu_ppwm_u_pwm__243_ net213 VGND VPWR net595 hold210/A clknet_5_1__leaf_clk sg13g2_dfrbpq_2
Xu_ppwm_u_pwm__174_ u_ppwm_u_pwm__175_/B u_ppwm_u_pwm__202_/B u_ppwm_u_pwm__174_/B
+ VPWR VGND sg13g2_xnor2_1
XFILLER_6_764 VPWR VGND sg13g2_decap_8
XFILLER_10_782 VPWR VGND sg13g2_decap_8
Xclkbuf_5_14__f_clk clknet_4_7_0_clk clknet_5_14__leaf_clk VPWR VGND sg13g2_buf_8
XFILLER_2_970 VPWR VGND sg13g2_decap_8
XFILLER_37_602 VPWR VGND sg13g2_decap_8
XFILLER_49_495 VPWR VGND sg13g2_decap_8
XFILLER_37_679 VPWR VGND sg13g2_decap_8
XFILLER_45_690 VPWR VGND sg13g2_decap_8
XFILLER_17_370 VPWR VGND sg13g2_decap_8
XFILLER_18_893 VPWR VGND sg13g2_decap_8
XFILLER_33_830 VPWR VGND sg13g2_decap_8
XFILLER_32_351 VPWR VGND sg13g2_decap_4
XFILLER_20_524 VPWR VGND sg13g2_decap_8
Xu_ppwm_u_ex__0987_ u_ppwm_u_ex__0987_/X net344 u_ppwm_u_ex__0987_/B u_ppwm_u_ex__0987_/C
+ VPWR VGND sg13g2_and3_1
XFILLER_9_591 VPWR VGND sg13g2_decap_8
XFILLER_28_602 VPWR VGND sg13g2_decap_8
XFILLER_28_679 VPWR VGND sg13g2_decap_8
XFILLER_43_638 VPWR VGND sg13g2_decap_8
XFILLER_27_178 VPWR VGND sg13g2_fill_2
XFILLER_36_690 VPWR VGND sg13g2_decap_8
XFILLER_24_852 VPWR VGND sg13g2_decap_8
XFILLER_23_362 VPWR VGND sg13g2_decap_4
XFILLER_11_535 VPWR VGND sg13g2_decap_8
XFILLER_3_756 VPWR VGND sg13g2_decap_8
XFILLER_47_933 VPWR VGND sg13g2_decap_8
XFILLER_19_613 VPWR VGND sg13g2_decap_8
XFILLER_18_112 VPWR VGND sg13g2_decap_4
XFILLER_20_1028 VPWR VGND sg13g2_fill_1
XFILLER_46_454 VPWR VGND sg13g2_decap_8
XFILLER_18_167 VPWR VGND sg13g2_fill_2
XFILLER_34_605 VPWR VGND sg13g2_decap_8
Xu_ppwm_u_ex__0910_ VGND VPWR u_ppwm_u_ex__0908_/Y u_ppwm_u_ex__0929_/B u_ppwm_u_ex__0910_/Y
+ net349 sg13g2_a21oi_1
XFILLER_42_671 VPWR VGND sg13g2_decap_8
XFILLER_14_362 VPWR VGND sg13g2_decap_4
XFILLER_15_885 VPWR VGND sg13g2_decap_8
XFILLER_30_822 VPWR VGND sg13g2_decap_8
XFILLER_14_384 VPWR VGND sg13g2_fill_1
Xu_ppwm_u_ex__0841_ u_ppwm_u_ex__0841_/A u_ppwm_u_ex__0841_/B u_ppwm_u_ex__1123_/D
+ VPWR VGND sg13g2_nor2_1
Xu_ppwm_u_ex__0772_ u_ppwm_u_ex__0772_/Y u_ppwm_u_ex__0772_/A u_ppwm_u_ex__0772_/B
+ VPWR VGND sg13g2_nand2_1
XFILLER_30_899 VPWR VGND sg13g2_decap_8
Xu_ppwm_u_mem__0984_ VGND VPWR u_ppwm_u_mem__0640_/Y net385 u_ppwm_u_mem__1162_/D
+ u_ppwm_u_mem__0983_/Y sg13g2_a21oi_1
Xu_ppwm_u_pwm__226_ u_ppwm_u_pwm__226_/X u_ppwm_u_pwm__226_/A u_ppwm_u_pwm__227_/C
+ u_ppwm_u_pwm__226_/C VPWR VGND sg13g2_and3_1
XFILLER_6_561 VPWR VGND sg13g2_decap_8
Xu_ppwm_u_pwm__157_ net476 VPWR u_ppwm_u_pwm__157_/Y VGND u_ppwm_u_pwm__160_/B u_ppwm_u_pwm__160_/C
+ sg13g2_o21ai_1
Xu_ppwm_u_global_counter__175_ net67 VGND VPWR u_ppwm_u_global_counter__175_/D hold266/A
+ clknet_5_16__leaf_clk sg13g2_dfrbpq_2
XFILLER_38_966 VPWR VGND sg13g2_decap_8
XFILLER_37_476 VPWR VGND sg13g2_decap_8
XFILLER_18_690 VPWR VGND sg13g2_decap_8
XFILLER_25_627 VPWR VGND sg13g2_decap_8
XFILLER_21_855 VPWR VGND sg13g2_decap_8
XFILLER_20_376 VPWR VGND sg13g2_fill_1
XFILLER_47_229 VPWR VGND sg13g2_decap_4
XFILLER_46_34 VPWR VGND sg13g2_fill_2
XFILLER_29_955 VPWR VGND sg13g2_decap_8
XFILLER_28_476 VPWR VGND sg13g2_decap_8
XFILLER_44_936 VPWR VGND sg13g2_decap_8
XFILLER_43_402 VPWR VGND sg13g2_fill_1
XFILLER_12_800 VPWR VGND sg13g2_decap_8
XFILLER_8_815 VPWR VGND sg13g2_decap_8
XFILLER_12_877 VPWR VGND sg13g2_decap_8
XFILLER_7_325 VPWR VGND sg13g2_decap_8
XFILLER_3_553 VPWR VGND sg13g2_decap_8
XFILLER_47_730 VPWR VGND sg13g2_decap_8
Xu_ppwm_u_ex__1040_ u_ppwm_u_ex__1040_/A u_ppwm_u_ex__1040_/B u_ppwm_u_ex__1040_/Y
+ VPWR VGND sg13g2_nor2_1
Xu_ppwm_u_mem__1183_ net137 VGND VPWR u_ppwm_u_mem__1183_/D hold55/A clknet_5_28__leaf_clk
+ sg13g2_dfrbpq_1
XFILLER_46_262 VPWR VGND sg13g2_decap_8
XFILLER_19_487 VPWR VGND sg13g2_decap_8
XFILLER_35_947 VPWR VGND sg13g2_decap_8
XFILLER_34_446 VPWR VGND sg13g2_fill_1
XFILLER_15_682 VPWR VGND sg13g2_decap_8
Xu_ppwm_u_ex__0824_ net450 hold264/A net375 u_ppwm_u_ex__0827_/D VPWR VGND sg13g2_mux2_1
XFILLER_30_696 VPWR VGND sg13g2_decap_8
Xu_ppwm_u_ex__0755_ VPWR VGND u_ppwm_u_ex__0754_/Y u_ppwm_u_ex__0751_/Y u_ppwm_u_ex__0753_/Y
+ u_ppwm_u_ex__0575_/Y u_ppwm_u_ex__0755_/Y hold288/A sg13g2_a221oi_1
Xu_ppwm_u_mem__0967_ net483 VPWR u_ppwm_u_mem__0967_/Y VGND net565 net384 sg13g2_o21ai_1
Xu_ppwm_u_mem__0898_ VGND VPWR u_ppwm_u_mem__0683_/Y net413 u_ppwm_u_mem__1119_/D
+ u_ppwm_u_mem__0897_/Y sg13g2_a21oi_1
Xu_ppwm_u_ex__0686_ net443 net434 u_ppwm_u_ex__0689_/C VPWR VGND sg13g2_nor2b_1
Xu_ppwm_u_pwm__209_ hold169/A hold213/A u_ppwm_u_pwm__209_/Y VPWR VGND sg13g2_nor2b_1
XFILLER_42_0 VPWR VGND sg13g2_decap_4
Xu_ppwm_u_mem__1116__119 VPWR VGND net119 sg13g2_tiehi
Xu_ppwm_u_global_counter__158_ u_ppwm_u_global_counter__158_/B net642 hold260/A VPWR
+ VGND sg13g2_xor2_1
XFILLER_26_914 VPWR VGND sg13g2_decap_8
XFILLER_38_763 VPWR VGND sg13g2_decap_8
XFILLER_25_413 VPWR VGND sg13g2_decap_4
XFILLER_25_424 VPWR VGND sg13g2_decap_8
XFILLER_21_652 VPWR VGND sg13g2_decap_8
XFILLER_5_818 VPWR VGND sg13g2_decap_8
XFILLER_10_1027 VPWR VGND sg13g2_fill_2
XFILLER_48_527 VPWR VGND sg13g2_decap_8
XFILLER_0_567 VPWR VGND sg13g2_decap_8
XFILLER_29_752 VPWR VGND sg13g2_decap_8
XFILLER_44_733 VPWR VGND sg13g2_decap_8
XFILLER_17_958 VPWR VGND sg13g2_decap_8
XFILLER_16_468 VPWR VGND sg13g2_decap_8
XFILLER_32_928 VPWR VGND sg13g2_decap_8
XFILLER_25_991 VPWR VGND sg13g2_decap_8
XFILLER_40_961 VPWR VGND sg13g2_decap_8
XFILLER_8_612 VPWR VGND sg13g2_decap_8
XFILLER_12_674 VPWR VGND sg13g2_decap_8
XFILLER_8_689 VPWR VGND sg13g2_decap_8
Xu_ppwm_u_mem__0821_ VGND VPWR u_ppwm_u_mem__0819_/Y u_ppwm_u_mem__0820_/Y u_ppwm_u_mem__0821_/Y
+ net459 sg13g2_a21oi_1
XFILLER_7_199 VPWR VGND sg13g2_fill_2
Xu_ppwm_u_mem__0752_ u_ppwm_u_mem__0751_/Y VPWR u_ppwm/instr\[1\] VGND u_ppwm_u_mem__0738_/Y
+ u_ppwm_u_mem__0745_/Y sg13g2_o21ai_1
XFILLER_4_851 VPWR VGND sg13g2_decap_8
Xu_ppwm_u_mem__0683_ VPWR u_ppwm_u_mem__0683_/Y net564 VGND sg13g2_inv_1
XFILLER_26_1012 VPWR VGND sg13g2_decap_8
XFILLER_39_549 VPWR VGND sg13g2_decap_8
XFILLER_14_4 VPWR VGND sg13g2_decap_8
Xu_ppwm_u_ex__1023_ u_ppwm_u_ex__1023_/A u_ppwm_u_ex__1023_/B u_ppwm_u_ex__1023_/C
+ u_ppwm_u_ex__1023_/Y VPWR VGND sg13g2_nor3_1
Xu_ppwm_u_mem__1166_ net104 VGND VPWR net257 hold39/A clknet_5_18__leaf_clk sg13g2_dfrbpq_1
XFILLER_35_744 VPWR VGND sg13g2_decap_8
Xu_ppwm_u_mem__1097_ net156 VGND VPWR u_ppwm_u_mem__1097_/D hold155/A clknet_5_10__leaf_clk
+ sg13g2_dfrbpq_1
XFILLER_23_917 VPWR VGND sg13g2_decap_8
XFILLER_22_449 VPWR VGND sg13g2_decap_4
XFILLER_31_950 VPWR VGND sg13g2_decap_8
XFILLER_33_1005 VPWR VGND sg13g2_decap_8
Xu_ppwm_u_ex__0807_ net440 net375 u_ppwm_u_ex__0807_/X VPWR VGND sg13g2_and2_1
XFILLER_30_493 VPWR VGND sg13g2_decap_8
Xu_ppwm_u_ex__0738_ u_ppwm_u_ex__0738_/Y hold262/A u_ppwm_u_ex__0574_/Y net422 u_ppwm_u_ex__0573_/Y
+ VPWR VGND sg13g2_a22oi_1
Xu_ppwm_u_ex__0669_ u_ppwm_u_ex__0666_/Y VPWR u_ppwm_u_ex__0671_/A VGND u_ppwm_u_ex__0721_/A
+ hold284/A sg13g2_o21ai_1
XFILLER_45_508 VPWR VGND sg13g2_decap_8
XFILLER_27_14 VPWR VGND sg13g2_fill_2
XFILLER_26_711 VPWR VGND sg13g2_decap_8
XFILLER_38_560 VPWR VGND sg13g2_decap_8
XFILLER_26_788 VPWR VGND sg13g2_decap_8
XFILLER_13_438 VPWR VGND sg13g2_fill_2
Xclkbuf_4_8_0_clk clknet_0_clk clknet_4_8_0_clk VPWR VGND sg13g2_buf_8
XFILLER_25_287 VPWR VGND sg13g2_decap_8
XFILLER_41_769 VPWR VGND sg13g2_decap_8
XFILLER_22_994 VPWR VGND sg13g2_decap_8
XFILLER_5_615 VPWR VGND sg13g2_decap_8
XFILLER_1_832 VPWR VGND sg13g2_decap_8
XFILLER_49_803 VPWR VGND sg13g2_decap_8
XFILLER_0_331 VPWR VGND sg13g2_fill_1
XFILLER_0_364 VPWR VGND sg13g2_decap_8
XFILLER_36_508 VPWR VGND sg13g2_decap_8
XFILLER_1_1014 VPWR VGND sg13g2_decap_8
XFILLER_44_530 VPWR VGND sg13g2_decap_8
XFILLER_17_755 VPWR VGND sg13g2_decap_8
Xu_ppwm_u_mem__1020_ VGND VPWR u_ppwm_u_mem__0622_/Y net408 u_ppwm_u_mem__1180_/D
+ u_ppwm_u_mem__1019_/Y sg13g2_a21oi_1
XFILLER_32_725 VPWR VGND sg13g2_decap_8
XFILLER_16_298 VPWR VGND sg13g2_fill_1
XFILLER_20_909 VPWR VGND sg13g2_decap_8
XFILLER_12_471 VPWR VGND sg13g2_decap_8
XFILLER_13_994 VPWR VGND sg13g2_decap_8
XFILLER_9_976 VPWR VGND sg13g2_decap_8
XFILLER_8_486 VPWR VGND sg13g2_decap_8
Xu_ppwm_u_mem__0804_ u_ppwm_u_mem__0804_/Y hold199/A net469 VPWR VGND sg13g2_nand2b_1
Xu_ppwm_u_mem__0735_ u_ppwm_u_mem__0735_/Y u_ppwm_u_mem__0831_/A u_ppwm_u_mem__0735_/B
+ VPWR VGND sg13g2_nand2_1
Xu_ppwm_u_mem__0666_ VPWR u_ppwm_u_mem__0666_/Y net547 VGND sg13g2_inv_1
XFILLER_48_891 VPWR VGND sg13g2_decap_8
XFILLER_27_519 VPWR VGND sg13g2_decap_8
Xu_ppwm_u_ex__1006_ u_ppwm_u_ex__1006_/Y hold299/A net370 VPWR VGND sg13g2_xnor2_1
XFILLER_35_541 VPWR VGND sg13g2_decap_8
XFILLER_23_714 VPWR VGND sg13g2_decap_8
Xu_ppwm_u_mem__1149_ net171 VGND VPWR u_ppwm_u_mem__1149_/D hold183/A clknet_5_12__leaf_clk
+ sg13g2_dfrbpq_1
XFILLER_18_508 VPWR VGND sg13g2_decap_8
XFILLER_46_839 VPWR VGND sg13g2_decap_8
XFILLER_45_316 VPWR VGND sg13g2_fill_1
XFILLER_26_585 VPWR VGND sg13g2_decap_8
XFILLER_41_566 VPWR VGND sg13g2_decap_8
XFILLER_14_758 VPWR VGND sg13g2_decap_8
Xu_ppwm_u_pwm__190_ net478 VPWR u_ppwm_u_pwm__190_/Y VGND net443 net379 sg13g2_o21ai_1
XFILLER_10_964 VPWR VGND sg13g2_decap_8
XFILLER_22_791 VPWR VGND sg13g2_decap_8
XFILLER_6_946 VPWR VGND sg13g2_decap_8
XFILLER_5_412 VPWR VGND sg13g2_decap_8
Xu_ppwm_u_mem__1105__140 VPWR VGND net140 sg13g2_tiehi
XFILLER_5_489 VPWR VGND sg13g2_decap_8
XFILLER_49_600 VPWR VGND sg13g2_decap_8
XFILLER_0_150 VPWR VGND sg13g2_decap_8
XFILLER_23_1015 VPWR VGND sg13g2_decap_8
XFILLER_49_677 VPWR VGND sg13g2_decap_8
XFILLER_45_872 VPWR VGND sg13g2_decap_8
XFILLER_17_552 VPWR VGND sg13g2_decap_8
Xu_ppwm_u_mem__1003_ net503 VPWR u_ppwm_u_mem__1003_/Y VGND net339 net408 sg13g2_o21ai_1
XFILLER_32_522 VPWR VGND sg13g2_decap_8
XFILLER_20_706 VPWR VGND sg13g2_decap_8
XFILLER_32_599 VPWR VGND sg13g2_decap_8
XFILLER_13_791 VPWR VGND sg13g2_decap_8
XFILLER_8_272 VPWR VGND sg13g2_decap_4
XFILLER_8_250 VPWR VGND sg13g2_fill_2
XFILLER_9_773 VPWR VGND sg13g2_decap_8
Xu_ppwm_u_mem__0718_ net622 u_ppwm_u_mem__0718_/C u_ppwm_u_mem__0720_/C VPWR VGND
+ net311 sg13g2_nand3b_1
Xu_ppwm_u_mem__0649_ VPWR u_ppwm_u_mem__0649_/Y net231 VGND sg13g2_inv_1
XFILLER_39_1011 VPWR VGND sg13g2_decap_8
XFILLER_36_872 VPWR VGND sg13g2_decap_8
XFILLER_23_511 VPWR VGND sg13g2_decap_8
XFILLER_11_717 VPWR VGND sg13g2_decap_8
XFILLER_23_588 VPWR VGND sg13g2_decap_8
XFILLER_10_249 VPWR VGND sg13g2_fill_2
XFILLER_3_938 VPWR VGND sg13g2_decap_8
Xhold250 hold250/A VPWR VGND net633 sg13g2_dlygate4sd3_1
Xhold261 hold261/A VPWR VGND net644 sg13g2_dlygate4sd3_1
Xhold294 hold294/A VPWR VGND net677 sg13g2_dlygate4sd3_1
Xhold283 hold283/A VPWR VGND net666 sg13g2_dlygate4sd3_1
XFILLER_2_459 VPWR VGND sg13g2_decap_8
Xhold272 hold272/A VPWR VGND net655 sg13g2_dlygate4sd3_1
XFILLER_49_89 VPWR VGND sg13g2_decap_8
XFILLER_46_636 VPWR VGND sg13g2_decap_8
XFILLER_27_883 VPWR VGND sg13g2_decap_8
XFILLER_42_853 VPWR VGND sg13g2_decap_8
XFILLER_14_555 VPWR VGND sg13g2_decap_8
XFILLER_41_352 VPWR VGND sg13g2_fill_1
Xu_ppwm_u_pwm__239__199 VPWR VGND net199 sg13g2_tiehi
Xu_ppwm_u_pwm__242_ net215 VGND VPWR u_ppwm_u_pwm__242_/D hold245/A clknet_5_1__leaf_clk
+ sg13g2_dfrbpq_2
XFILLER_10_761 VPWR VGND sg13g2_decap_8
Xu_ppwm_u_mem__1181__153 VPWR VGND net153 sg13g2_tiehi
XFILLER_6_743 VPWR VGND sg13g2_decap_8
Xu_ppwm_u_pwm__173_ net594 u_ppwm_u_pwm__173_/B hold212/A VPWR VGND sg13g2_nor2_1
XFILLER_5_264 VPWR VGND sg13g2_fill_2
XFILLER_49_474 VPWR VGND sg13g2_decap_8
XFILLER_37_658 VPWR VGND sg13g2_decap_8
XFILLER_18_872 VPWR VGND sg13g2_decap_8
XFILLER_25_809 VPWR VGND sg13g2_decap_8
XFILLER_20_503 VPWR VGND sg13g2_decap_8
XFILLER_33_886 VPWR VGND sg13g2_decap_8
Xu_ppwm_u_ex__0986_ VGND VPWR net430 u_ppwm_u_ex__0785_/Y u_ppwm_u_ex__0987_/C u_ppwm_u_ex__0985_/Y
+ sg13g2_a21oi_1
XFILLER_9_570 VPWR VGND sg13g2_decap_8
XFILLER_28_658 VPWR VGND sg13g2_decap_8
XFILLER_43_617 VPWR VGND sg13g2_decap_8
XFILLER_24_831 VPWR VGND sg13g2_decap_8
XFILLER_11_514 VPWR VGND sg13g2_decap_8
Xclkbuf_5_20__f_clk clknet_4_10_0_clk clknet_5_20__leaf_clk VPWR VGND sg13g2_buf_8
XFILLER_3_735 VPWR VGND sg13g2_decap_8
XFILLER_47_912 VPWR VGND sg13g2_decap_8
XFILLER_46_433 VPWR VGND sg13g2_decap_8
XFILLER_20_1007 VPWR VGND sg13g2_decap_8
XFILLER_47_989 VPWR VGND sg13g2_decap_8
XFILLER_19_669 VPWR VGND sg13g2_decap_8
XFILLER_18_179 VPWR VGND sg13g2_fill_1
XFILLER_27_680 VPWR VGND sg13g2_decap_8
XFILLER_15_864 VPWR VGND sg13g2_decap_8
XFILLER_42_650 VPWR VGND sg13g2_decap_8
XFILLER_14_341 VPWR VGND sg13g2_fill_2
XFILLER_30_801 VPWR VGND sg13g2_decap_8
XFILLER_41_182 VPWR VGND sg13g2_decap_4
XFILLER_41_160 VPWR VGND sg13g2_decap_4
Xu_ppwm_u_ex__0840_ net496 VPWR u_ppwm_u_ex__0841_/B VGND u_ppwm_u_ex__1010_/A u_ppwm_u_ex__0838_/Y
+ sg13g2_o21ai_1
Xu_ppwm_u_ex__0771_ u_ppwm_u_ex__0771_/A u_ppwm_u_ex__0771_/B u_ppwm_u_ex__0771_/C
+ u_ppwm_u_ex__0772_/B VPWR VGND sg13g2_nor3_1
XFILLER_30_878 VPWR VGND sg13g2_decap_8
Xu_ppwm_u_mem__0983_ net487 VPWR u_ppwm_u_mem__0983_/Y VGND net252 net385 sg13g2_o21ai_1
Xu_ppwm_u_pwm__225_ VGND VPWR hold156/A u_ppwm_u_pwm__160_/A u_ppwm_u_pwm__226_/C
+ u_ppwm_u_pwm__227_/D sg13g2_a21oi_1
XFILLER_6_540 VPWR VGND sg13g2_decap_8
Xu_ppwm_u_pwm__156_ u_ppwm_u_pwm__175_/A net613 u_ppwm_u_pwm__156_/C u_ppwm_u_pwm__237_/D
+ VPWR VGND sg13g2_nor3_1
Xu_ppwm_u_global_counter__174_ net71 VGND VPWR net646 hold262/A clknet_5_17__leaf_clk
+ sg13g2_dfrbpq_2
XFILLER_2_95 VPWR VGND sg13g2_fill_1
XFILLER_38_945 VPWR VGND sg13g2_decap_8
XFILLER_25_606 VPWR VGND sg13g2_decap_8
XFILLER_24_105 VPWR VGND sg13g2_fill_2
XFILLER_33_683 VPWR VGND sg13g2_decap_8
XFILLER_21_834 VPWR VGND sg13g2_decap_8
XFILLER_32_182 VPWR VGND sg13g2_decap_4
Xu_ppwm_u_ex__0969_ u_ppwm_u_ex__1099_/A u_ppwm_u_ex__0968_/Y u_ppwm_u_ex__0983_/A
+ u_ppwm_u_ex__0935_/X u_ppwm_u_ex__0804_/Y VPWR VGND sg13g2_a22oi_1
XFILLER_48_709 VPWR VGND sg13g2_decap_8
XFILLER_0_749 VPWR VGND sg13g2_decap_8
XFILLER_29_934 VPWR VGND sg13g2_decap_8
XFILLER_44_915 VPWR VGND sg13g2_decap_8
XFILLER_28_455 VPWR VGND sg13g2_decap_8
XFILLER_16_639 VPWR VGND sg13g2_decap_8
XFILLER_15_138 VPWR VGND sg13g2_fill_1
XFILLER_12_856 VPWR VGND sg13g2_decap_8
XFILLER_3_532 VPWR VGND sg13g2_decap_8
XFILLER_4_1012 VPWR VGND sg13g2_decap_8
Xfanout390 net391 net390 VPWR VGND sg13g2_buf_8
Xu_ppwm_u_mem__1182_ net145 VGND VPWR u_ppwm_u_mem__1182_/D hold114/A clknet_5_29__leaf_clk
+ sg13g2_dfrbpq_1
XFILLER_47_786 VPWR VGND sg13g2_decap_8
XFILLER_46_274 VPWR VGND sg13g2_fill_2
XFILLER_35_926 VPWR VGND sg13g2_decap_8
XFILLER_43_981 VPWR VGND sg13g2_decap_8
XFILLER_15_661 VPWR VGND sg13g2_decap_8
XFILLER_22_609 VPWR VGND sg13g2_decap_8
XFILLER_14_182 VPWR VGND sg13g2_fill_1
Xu_ppwm_u_ex__0823_ u_ppwm_u_ex__0801_/B u_ppwm_u_ex__0822_/X net368 u_ppwm_u_ex__0823_/X
+ VPWR VGND sg13g2_mux2_1
XFILLER_30_675 VPWR VGND sg13g2_decap_8
Xu_ppwm_u_ex__0754_ u_ppwm_u_ex__0754_/Y u_ppwm_u_ex__0606_/Y net440 u_ppwm_u_ex__0751_/B
+ net438 VPWR VGND sg13g2_a22oi_1
Xu_ppwm_u_pwm__208_ u_ppwm_u_pwm__207_/Y VPWR u_ppwm_u_pwm__208_/Y VGND u_ppwm_u_pwm__214_/A
+ u_ppwm_u_pwm__214_/B sg13g2_o21ai_1
Xu_ppwm_u_mem__0966_ VGND VPWR u_ppwm_u_mem__0649_/Y net383 hold15/A u_ppwm_u_mem__0965_/Y
+ sg13g2_a21oi_1
Xu_ppwm_u_mem__0897_ net500 VPWR u_ppwm_u_mem__0897_/Y VGND net273 net413 sg13g2_o21ai_1
Xu_ppwm_u_ex__0685_ net444 net436 u_ppwm_u_ex__0685_/X VPWR VGND sg13g2_xor2_1
Xu_ppwm_u_pwm__139_ VPWR u_ppwm_u_pwm__160_/A net583 VGND sg13g2_inv_1
XFILLER_35_0 VPWR VGND sg13g2_decap_8
XFILLER_29_208 VPWR VGND sg13g2_decap_8
Xu_ppwm_u_mem__1155__147 VPWR VGND net147 sg13g2_tiehi
Xu_ppwm_u_global_counter__157_ u_ppwm_u_global_counter__178_/D net480 u_ppwm_u_global_counter__157_/B
+ u_ppwm_u_global_counter__158_/B VPWR VGND sg13g2_and3_1
XFILLER_38_742 VPWR VGND sg13g2_decap_8
Xu_ppwm_u_ex__1099_ u_ppwm_u_ex__1100_/C u_ppwm_u_ex__1099_/A net341 VPWR VGND sg13g2_nand2_1
XFILLER_13_609 VPWR VGND sg13g2_decap_8
XFILLER_21_631 VPWR VGND sg13g2_decap_8
XFILLER_20_152 VPWR VGND sg13g2_decap_8
XFILLER_20_163 VPWR VGND sg13g2_fill_2
XFILLER_10_1006 VPWR VGND sg13g2_decap_8
XFILLER_0_546 VPWR VGND sg13g2_decap_8
XFILLER_48_506 VPWR VGND sg13g2_decap_8
XFILLER_29_731 VPWR VGND sg13g2_decap_8
XFILLER_44_712 VPWR VGND sg13g2_decap_8
XFILLER_17_937 VPWR VGND sg13g2_decap_8
XFILLER_32_907 VPWR VGND sg13g2_decap_8
XFILLER_44_789 VPWR VGND sg13g2_decap_8
XFILLER_25_970 VPWR VGND sg13g2_decap_8
XFILLER_31_406 VPWR VGND sg13g2_decap_4
XFILLER_40_940 VPWR VGND sg13g2_decap_8
XFILLER_31_428 VPWR VGND sg13g2_decap_4
XFILLER_12_653 VPWR VGND sg13g2_decap_8
XFILLER_7_112 VPWR VGND sg13g2_fill_1
XFILLER_11_163 VPWR VGND sg13g2_fill_1
Xu_ppwm_u_mem__0820_ u_ppwm_u_mem__0820_/Y hold141/A net468 VPWR VGND sg13g2_nand2b_1
XFILLER_8_668 VPWR VGND sg13g2_decap_8
XFILLER_7_178 VPWR VGND sg13g2_fill_1
Xu_ppwm_u_mem__0751_ u_ppwm_u_mem__0751_/Y u_ppwm_u_mem__0831_/A u_ppwm_u_mem__0751_/B
+ VPWR VGND sg13g2_nand2_1
Xu_ppwm_u_mem__0682_ VPWR u_ppwm_u_mem__0682_/Y net273 VGND sg13g2_inv_1
XFILLER_4_830 VPWR VGND sg13g2_decap_8
XFILLER_39_528 VPWR VGND sg13g2_decap_8
Xu_ppwm_u_ex__1022_ VGND VPWR u_ppwm_u_ex__1020_/Y u_ppwm_u_ex__1021_/Y u_ppwm_u_ex__1023_/C
+ net352 sg13g2_a21oi_1
XFILLER_47_583 VPWR VGND sg13g2_decap_8
XFILLER_34_200 VPWR VGND sg13g2_fill_2
XFILLER_35_723 VPWR VGND sg13g2_decap_8
Xu_ppwm_u_mem__1165_ net108 VGND VPWR u_ppwm_u_mem__1165_/D hold120/A clknet_5_18__leaf_clk
+ sg13g2_dfrbpq_1
XFILLER_34_211 VPWR VGND sg13g2_decap_4
Xu_ppwm_u_mem__1096_ net158 VGND VPWR net240 hold22/A clknet_5_10__leaf_clk sg13g2_dfrbpq_1
XFILLER_33_1028 VPWR VGND sg13g2_fill_1
Xu_ppwm_u_ex__0806_ net361 u_ppwm_u_ex__0933_/A u_ppwm_u_ex__0806_/Y VPWR VGND sg13g2_nor2_1
Xu_ppwm_u_ex__0737_ u_ppwm_u_ex__0736_/Y VPWR u_ppwm_u_ex__0737_/Y VGND u_ppwm_u_ex__0731_/Y
+ u_ppwm_u_ex__0735_/Y sg13g2_o21ai_1
Xu_ppwm_u_mem__0949_ net483 VPWR u_ppwm_u_mem__0949_/Y VGND hold174/A net382 sg13g2_o21ai_1
Xu_ppwm_u_ex__0668_ u_ppwm_u_ex__0667_/Y VPWR u_ppwm_u_ex__0668_/Y VGND u_ppwm_u_ex__0721_/A
+ net425 sg13g2_o21ai_1
Xu_ppwm_u_ex__0599_ VPWR u_ppwm_u_ex__0599_/Y hold246/A VGND sg13g2_inv_1
Xu_ppwm_u_ex__1137__34 VPWR VGND net34 sg13g2_tiehi
XFILLER_26_767 VPWR VGND sg13g2_decap_8
XFILLER_41_748 VPWR VGND sg13g2_decap_8
XFILLER_22_973 VPWR VGND sg13g2_decap_8
XFILLER_49_1013 VPWR VGND sg13g2_decap_8
XFILLER_4_148 VPWR VGND sg13g2_fill_2
XFILLER_4_19 VPWR VGND sg13g2_fill_1
XFILLER_1_811 VPWR VGND sg13g2_decap_8
XFILLER_0_310 VPWR VGND sg13g2_decap_8
XFILLER_0_321 VPWR VGND sg13g2_fill_2
Xu_ppwm_u_mem__1097__156 VPWR VGND net156 sg13g2_tiehi
XFILLER_0_343 VPWR VGND sg13g2_decap_8
XFILLER_1_888 VPWR VGND sg13g2_decap_8
XFILLER_49_859 VPWR VGND sg13g2_decap_8
XFILLER_48_369 VPWR VGND sg13g2_fill_2
XFILLER_16_200 VPWR VGND sg13g2_decap_8
XFILLER_17_734 VPWR VGND sg13g2_decap_8
XFILLER_32_704 VPWR VGND sg13g2_decap_8
XFILLER_44_586 VPWR VGND sg13g2_decap_8
XFILLER_31_203 VPWR VGND sg13g2_decap_8
XFILLER_31_247 VPWR VGND sg13g2_decap_4
XFILLER_13_973 VPWR VGND sg13g2_decap_8
XFILLER_9_955 VPWR VGND sg13g2_decap_8
XFILLER_8_465 VPWR VGND sg13g2_decap_8
Xu_ppwm_u_mem__0803_ u_ppwm_u_mem__0803_/Y hold43/A net469 VPWR VGND sg13g2_nand2_1
Xu_ppwm_u_mem__0734_ net456 u_ppwm_u_mem__0731_/X u_ppwm_u_mem__0733_/X u_ppwm_u_mem__0730_/X
+ u_ppwm_u_mem__0732_/X net461 u_ppwm_u_mem__0735_/B VPWR VGND sg13g2_mux4_1
Xu_ppwm_u_mem__0665_ VPWR u_ppwm_u_mem__0665_/Y net300 VGND sg13g2_inv_1
XFILLER_48_870 VPWR VGND sg13g2_decap_8
Xu_ppwm_u_ex__1005_ u_ppwm_u_ex__1005_/Y hold299/A net370 VPWR VGND sg13g2_nand2_1
XFILLER_35_520 VPWR VGND sg13g2_decap_8
Xu_ppwm_u_mem__1148_ net174 VGND VPWR net522 hold138/A clknet_5_8__leaf_clk sg13g2_dfrbpq_1
Xclkbuf_5_1__f_clk clknet_4_0_0_clk clknet_5_1__leaf_clk VPWR VGND sg13g2_buf_8
XFILLER_35_597 VPWR VGND sg13g2_decap_8
Xu_ppwm_u_mem__1079_ VGND VPWR hold248/A u_ppwm_u_mem__1077_/S hold136/A net518 sg13g2_a21oi_1
XFILLER_22_236 VPWR VGND sg13g2_decap_8
XFILLER_22_247 VPWR VGND sg13g2_fill_2
XFILLER_38_14 VPWR VGND sg13g2_fill_2
XFILLER_46_818 VPWR VGND sg13g2_decap_8
XFILLER_39_892 VPWR VGND sg13g2_decap_8
XFILLER_26_564 VPWR VGND sg13g2_decap_8
XFILLER_13_225 VPWR VGND sg13g2_fill_2
XFILLER_14_737 VPWR VGND sg13g2_decap_8
XFILLER_41_545 VPWR VGND sg13g2_decap_8
XFILLER_22_770 VPWR VGND sg13g2_decap_8
XFILLER_10_943 VPWR VGND sg13g2_decap_8
XFILLER_6_925 VPWR VGND sg13g2_decap_8
XFILLER_5_468 VPWR VGND sg13g2_decap_8
XFILLER_1_685 VPWR VGND sg13g2_decap_8
XFILLER_49_656 VPWR VGND sg13g2_decap_8
XFILLER_17_531 VPWR VGND sg13g2_decap_8
XFILLER_45_851 VPWR VGND sg13g2_decap_8
Xu_ppwm_u_mem__1002_ VGND VPWR u_ppwm_u_mem__0631_/Y net390 hold128/A u_ppwm_u_mem__1001_/Y
+ sg13g2_a21oi_1
XFILLER_32_501 VPWR VGND sg13g2_decap_8
XFILLER_13_770 VPWR VGND sg13g2_decap_8
XFILLER_32_578 VPWR VGND sg13g2_decap_8
XFILLER_9_752 VPWR VGND sg13g2_decap_8
XFILLER_5_73 VPWR VGND sg13g2_fill_2
Xu_ppwm_u_mem__0717_ u_ppwm_u_mem__1081_/A net477 VPWR VGND sg13g2_inv_2
XFILLER_5_95 VPWR VGND sg13g2_fill_1
Xu_ppwm_u_mem__0648_ VPWR u_ppwm_u_mem__0648_/Y net567 VGND sg13g2_inv_1
Xclkbuf_4_7_0_clk clknet_0_clk clknet_4_7_0_clk VPWR VGND sg13g2_buf_8
XFILLER_27_317 VPWR VGND sg13g2_decap_8
XFILLER_36_851 VPWR VGND sg13g2_decap_8
XFILLER_23_567 VPWR VGND sg13g2_decap_8
Xu_ppwm_u_ex__1130__40 VPWR VGND net40 sg13g2_tiehi
XFILLER_3_917 VPWR VGND sg13g2_decap_8
Xhold262 hold262/A VPWR VGND net645 sg13g2_dlygate4sd3_1
Xhold251 hold251/A VPWR VGND net634 sg13g2_dlygate4sd3_1
XFILLER_2_438 VPWR VGND sg13g2_decap_8
Xhold240 hold240/A VPWR VGND net623 sg13g2_dlygate4sd3_1
XFILLER_49_35 VPWR VGND sg13g2_decap_4
Xhold295 hold295/A VPWR VGND net678 sg13g2_dlygate4sd3_1
Xhold284 hold284/A VPWR VGND net667 sg13g2_dlygate4sd3_1
Xhold273 hold273/A VPWR VGND net656 sg13g2_dlygate4sd3_1
XFILLER_49_68 VPWR VGND sg13g2_decap_8
XFILLER_46_615 VPWR VGND sg13g2_decap_8
XFILLER_27_862 VPWR VGND sg13g2_decap_8
XFILLER_42_832 VPWR VGND sg13g2_decap_8
XFILLER_14_534 VPWR VGND sg13g2_decap_8
XFILLER_41_375 VPWR VGND sg13g2_decap_8
Xu_ppwm_u_pwm__241_ net217 VGND VPWR net621 hold236/A clknet_5_0__leaf_clk sg13g2_dfrbpq_2
XFILLER_10_740 VPWR VGND sg13g2_decap_8
Xu_ppwm_u_ex__1113__29 VPWR VGND net29 sg13g2_tiehi
Xu_ppwm_u_pwm__172_ u_ppwm_u_pwm__173_/B net476 u_ppwm_u_pwm__174_/B VPWR VGND sg13g2_nand2_1
XFILLER_6_722 VPWR VGND sg13g2_decap_8
XFILLER_6_799 VPWR VGND sg13g2_decap_8
XFILLER_30_81 VPWR VGND sg13g2_fill_1
XFILLER_39_7 VPWR VGND sg13g2_decap_4
XFILLER_1_482 VPWR VGND sg13g2_decap_8
XFILLER_49_453 VPWR VGND sg13g2_decap_8
XFILLER_37_637 VPWR VGND sg13g2_decap_8
XFILLER_18_851 VPWR VGND sg13g2_decap_8
XFILLER_33_865 VPWR VGND sg13g2_decap_8
Xu_ppwm_u_ex__0985_ net351 u_ppwm_u_ex__0985_/B u_ppwm_u_ex__0985_/Y VPWR VGND sg13g2_nor2_1
XFILLER_20_559 VPWR VGND sg13g2_decap_8
XFILLER_27_114 VPWR VGND sg13g2_fill_1
XFILLER_28_637 VPWR VGND sg13g2_decap_8
XFILLER_24_810 VPWR VGND sg13g2_decap_8
XFILLER_42_139 VPWR VGND sg13g2_fill_2
XFILLER_23_375 VPWR VGND sg13g2_fill_2
XFILLER_24_887 VPWR VGND sg13g2_decap_8
XFILLER_7_519 VPWR VGND sg13g2_decap_8
XFILLER_13_1015 VPWR VGND sg13g2_decap_8
XFILLER_3_714 VPWR VGND sg13g2_decap_8
XFILLER_2_202 VPWR VGND sg13g2_fill_2
XFILLER_19_648 VPWR VGND sg13g2_decap_8
XFILLER_47_968 VPWR VGND sg13g2_decap_8
XFILLER_46_489 VPWR VGND sg13g2_decap_8
XFILLER_15_843 VPWR VGND sg13g2_decap_8
XFILLER_33_139 VPWR VGND sg13g2_fill_1
XFILLER_30_857 VPWR VGND sg13g2_decap_8
Xu_ppwm_u_ex__0770_ hold298/A net424 u_ppwm_u_ex__0771_/C VPWR VGND sg13g2_nor2b_1
Xu_ppwm_u_mem__0982_ VGND VPWR u_ppwm_u_mem__0641_/Y net384 hold99/A u_ppwm_u_mem__0981_/Y
+ sg13g2_a21oi_1
Xu_ppwm_u_pwm__224_ hold241/A hold46/A u_ppwm_u_pwm__227_/D VPWR VGND sg13g2_nor2b_1
XFILLER_41_91 VPWR VGND sg13g2_fill_2
Xu_ppwm_u_pwm__155_ VPWR u_ppwm_u_pwm__156_/C u_ppwm_u_pwm__160_/C VGND sg13g2_inv_1
XFILLER_6_596 VPWR VGND sg13g2_decap_8
XFILLER_29_1011 VPWR VGND sg13g2_decap_8
XFILLER_38_924 VPWR VGND sg13g2_decap_8
XFILLER_49_283 VPWR VGND sg13g2_fill_1
XFILLER_49_272 VPWR VGND sg13g2_decap_8
Xu_ppwm_u_global_counter__173_ net75 VGND VPWR net607 hold222/A clknet_5_20__leaf_clk
+ sg13g2_dfrbpq_2
XFILLER_17_180 VPWR VGND sg13g2_decap_8
XFILLER_21_813 VPWR VGND sg13g2_decap_8
XFILLER_33_662 VPWR VGND sg13g2_decap_8
XFILLER_36_1026 VPWR VGND sg13g2_fill_2
Xu_ppwm_u_ex__0968_ u_ppwm_u_ex__0968_/Y u_ppwm_u_ex__0968_/A u_ppwm_u_ex__0968_/B
+ VPWR VGND sg13g2_nand2_1
Xu_ppwm_u_ex__0899_ VGND VPWR net368 u_ppwm_u_ex__0897_/Y u_ppwm_u_ex__0899_/Y u_ppwm_u_ex__0898_/Y
+ sg13g2_a21oi_1
XFILLER_0_728 VPWR VGND sg13g2_decap_8
XFILLER_29_913 VPWR VGND sg13g2_decap_8
XFILLER_16_618 VPWR VGND sg13g2_decap_8
XFILLER_11_301 VPWR VGND sg13g2_fill_1
XFILLER_12_835 VPWR VGND sg13g2_decap_8
XFILLER_24_684 VPWR VGND sg13g2_decap_8
XFILLER_11_389 VPWR VGND sg13g2_fill_1
XFILLER_3_511 VPWR VGND sg13g2_decap_8
XFILLER_11_83 VPWR VGND sg13g2_fill_2
XFILLER_3_588 VPWR VGND sg13g2_decap_8
Xfanout380 fanout380/A net380 VPWR VGND sg13g2_buf_8
Xfanout391 net404 net391 VPWR VGND sg13g2_buf_1
XFILLER_47_765 VPWR VGND sg13g2_decap_8
Xu_ppwm_u_mem__1181_ net153 VGND VPWR net297 hold79/A clknet_5_29__leaf_clk sg13g2_dfrbpq_1
XFILLER_35_905 VPWR VGND sg13g2_decap_8
XFILLER_36_91 VPWR VGND sg13g2_decap_8
XFILLER_43_960 VPWR VGND sg13g2_decap_8
Xu_ppwm_u_pwm__254__204 VPWR VGND net204 sg13g2_tiehi
XFILLER_15_640 VPWR VGND sg13g2_decap_8
Xu_ppwm_u_ex__0822_ net443 net434 net375 u_ppwm_u_ex__0822_/X VPWR VGND sg13g2_mux2_1
XFILLER_30_654 VPWR VGND sg13g2_decap_8
Xu_ppwm_u_ex__0753_ u_ppwm_u_ex__0752_/Y VPWR u_ppwm_u_ex__0753_/Y VGND net440 u_ppwm_u_ex__0606_/Y
+ sg13g2_o21ai_1
Xu_ppwm_u_pwm__207_ u_ppwm_u_pwm__207_/Y hold195/A hold250/A VPWR VGND sg13g2_nand2b_1
Xu_ppwm_u_mem__0965_ net483 VPWR u_ppwm_u_mem__0965_/Y VGND hold184/A net383 sg13g2_o21ai_1
Xu_ppwm_u_mem__0896_ VGND VPWR u_ppwm_u_mem__0684_/Y net402 hold38/A u_ppwm_u_mem__0895_/Y
+ sg13g2_a21oi_1
XFILLER_7_883 VPWR VGND sg13g2_decap_8
Xu_ppwm_u_ex__0684_ VPWR VGND u_ppwm_u_ex__0682_/Y u_ppwm_u_ex__0683_/Y u_ppwm_u_ex__0681_/Y
+ net438 u_ppwm_u_ex__0684_/Y u_ppwm_u_ex__0855_/A sg13g2_a221oi_1
Xu_ppwm_u_pwm__138_ u_ppwm_u_pwm__202_/B net571 VPWR VGND sg13g2_inv_2
XFILLER_38_721 VPWR VGND sg13g2_decap_8
Xu_ppwm_u_global_counter__156_ net423 u_ppwm_u_global_counter__156_/C net422 u_ppwm_u_global_counter__158_/B
+ VPWR VGND u_ppwm_u_global_counter__156_/D sg13g2_nand4_1
XFILLER_37_231 VPWR VGND sg13g2_decap_4
XFILLER_25_404 VPWR VGND sg13g2_decap_4
XFILLER_38_798 VPWR VGND sg13g2_decap_8
Xu_ppwm_u_ex__1098_ VGND VPWR u_ppwm_u_ex__1096_/Y u_ppwm_u_ex__1097_/Y u_ppwm_u_ex__1100_/B
+ net351 sg13g2_a21oi_1
XFILLER_26_949 VPWR VGND sg13g2_decap_8
XFILLER_25_459 VPWR VGND sg13g2_decap_8
XFILLER_21_610 VPWR VGND sg13g2_decap_8
XFILLER_32_16 VPWR VGND sg13g2_decap_4
XFILLER_21_687 VPWR VGND sg13g2_decap_8
XFILLER_0_525 VPWR VGND sg13g2_decap_8
XFILLER_29_710 VPWR VGND sg13g2_decap_8
XFILLER_28_220 VPWR VGND sg13g2_fill_2
XFILLER_17_916 VPWR VGND sg13g2_decap_8
XFILLER_29_787 VPWR VGND sg13g2_decap_8
XFILLER_44_768 VPWR VGND sg13g2_decap_8
XFILLER_24_481 VPWR VGND sg13g2_decap_8
XFILLER_12_632 VPWR VGND sg13g2_decap_8
XFILLER_40_996 VPWR VGND sg13g2_decap_8
XFILLER_8_647 VPWR VGND sg13g2_decap_8
XFILLER_7_157 VPWR VGND sg13g2_fill_2
Xu_ppwm_u_mem__0750_ net456 u_ppwm_u_mem__0747_/X u_ppwm_u_mem__0749_/X u_ppwm_u_mem__0746_/X
+ u_ppwm_u_mem__0748_/X net461 u_ppwm_u_mem__0751_/B VPWR VGND sg13g2_mux4_1
Xu_ppwm_u_mem__0681_ VPWR u_ppwm_u_mem__0681_/Y net234 VGND sg13g2_inv_1
XFILLER_4_886 VPWR VGND sg13g2_decap_8
XFILLER_3_385 VPWR VGND sg13g2_decap_8
XFILLER_39_507 VPWR VGND sg13g2_decap_8
Xu_ppwm_u_ex__1021_ u_ppwm_u_ex__1021_/Y fanout347/A hold246/A net348 hold272/A VPWR
+ VGND sg13g2_a22oi_1
XFILLER_47_562 VPWR VGND sg13g2_decap_8
XFILLER_47_90 VPWR VGND sg13g2_decap_8
Xu_ppwm_u_mem__1115__121 VPWR VGND net121 sg13g2_tiehi
Xu_ppwm_u_mem__1164_ net112 VGND VPWR u_ppwm_u_mem__1164_/D hold185/A clknet_5_24__leaf_clk
+ sg13g2_dfrbpq_1
XFILLER_35_702 VPWR VGND sg13g2_decap_8
Xu_ppwm_u_mem__1095_ net160 VGND VPWR u_ppwm_u_mem__1095_/D hold118/A clknet_5_10__leaf_clk
+ sg13g2_dfrbpq_1
XFILLER_34_267 VPWR VGND sg13g2_decap_8
XFILLER_35_779 VPWR VGND sg13g2_decap_8
XFILLER_16_982 VPWR VGND sg13g2_decap_8
XFILLER_31_985 VPWR VGND sg13g2_decap_8
Xu_ppwm_u_ex__0805_ net447 net438 net375 u_ppwm_u_ex__0933_/A VPWR VGND sg13g2_mux2_1
Xu_ppwm_u_ex__0736_ u_ppwm_u_ex__0736_/Y u_ppwm_u_ex__0598_/Y net437 u_ppwm_u_ex__0597_/Y
+ net436 VPWR VGND sg13g2_a22oi_1
Xu_ppwm_u_mem__0948_ VGND VPWR u_ppwm_u_mem__0658_/Y net389 u_ppwm_u_mem__1144_/D
+ u_ppwm_u_mem__0947_/Y sg13g2_a21oi_1
XFILLER_7_680 VPWR VGND sg13g2_decap_8
Xu_ppwm_u_mem__0879_ net490 VPWR u_ppwm_u_mem__0879_/Y VGND hold149/A net396 sg13g2_o21ai_1
Xu_ppwm_u_ex__0667_ u_ppwm_u_ex__0667_/Y hold297/A hold291/A VPWR VGND sg13g2_xnor2_1
Xu_ppwm_u_ex__0598_ VPWR u_ppwm_u_ex__0598_/Y hold222/A VGND sg13g2_inv_1
XFILLER_27_16 VPWR VGND sg13g2_fill_1
Xu_ppwm_u_global_counter__139_ net429 net630 u_ppwm_u_global_counter__172_/D VPWR
+ VGND sg13g2_nor2_1
XFILLER_26_746 VPWR VGND sg13g2_decap_8
XFILLER_38_595 VPWR VGND sg13g2_decap_8
XFILLER_14_919 VPWR VGND sg13g2_decap_8
XFILLER_41_727 VPWR VGND sg13g2_decap_8
XFILLER_25_278 VPWR VGND sg13g2_fill_1
XFILLER_22_952 VPWR VGND sg13g2_decap_8
XFILLER_21_484 VPWR VGND sg13g2_decap_8
XFILLER_4_138 VPWR VGND sg13g2_fill_1
XFILLER_1_867 VPWR VGND sg13g2_decap_8
XFILLER_49_838 VPWR VGND sg13g2_decap_8
XFILLER_0_399 VPWR VGND sg13g2_decap_8
XFILLER_17_713 VPWR VGND sg13g2_decap_8
XFILLER_29_584 VPWR VGND sg13g2_decap_8
XFILLER_44_565 VPWR VGND sg13g2_decap_8
Xu_ppwm_u_ex__1128__46 VPWR VGND net46 sg13g2_tiehi
XFILLER_16_267 VPWR VGND sg13g2_fill_1
XFILLER_31_226 VPWR VGND sg13g2_decap_8
XFILLER_13_952 VPWR VGND sg13g2_decap_8
XFILLER_9_934 VPWR VGND sg13g2_decap_8
XFILLER_40_793 VPWR VGND sg13g2_decap_8
Xu_ppwm_u_mem__0802_ net460 VPWR u_ppwm_u_mem__0802_/Y VGND hold131/A net466 sg13g2_o21ai_1
Xu_ppwm_u_mem__0733_ hold76/A hold53/A net463 u_ppwm_u_mem__0733_/X VPWR VGND sg13g2_mux2_1
Xu_ppwm_u_mem__0664_ VPWR u_ppwm_u_mem__0664_/Y net283 VGND sg13g2_inv_1
XFILLER_4_683 VPWR VGND sg13g2_decap_8
Xu_ppwm_u_ex__1004_ VGND VPWR u_ppwm_u_ex__1002_/Y u_ppwm_u_ex__1003_/Y u_ppwm_u_ex__1010_/B
+ net352 sg13g2_a21oi_1
Xu_ppwm_u_mem__1147_ net176 VGND VPWR u_ppwm_u_mem__1147_/D hold171/A clknet_5_8__leaf_clk
+ sg13g2_dfrbpq_1
Xu_ppwm_u_mem__1078_ u_ppwm_u_mem__1081_/A net632 u_ppwm_u_mem__1204_/D VPWR VGND
+ sg13g2_nor2_1
XFILLER_22_215 VPWR VGND sg13g2_decap_8
XFILLER_23_749 VPWR VGND sg13g2_decap_8
XFILLER_35_576 VPWR VGND sg13g2_decap_8
XFILLER_31_782 VPWR VGND sg13g2_decap_8
Xu_ppwm_u_ex__0719_ u_ppwm_u_ex__0719_/Y u_ppwm_u_ex__0719_/A hold259/A VPWR VGND
+ sg13g2_nand2_1
XFILLER_39_871 VPWR VGND sg13g2_decap_8
XFILLER_26_543 VPWR VGND sg13g2_decap_8
XFILLER_41_524 VPWR VGND sg13g2_decap_8
XFILLER_14_716 VPWR VGND sg13g2_decap_8
XFILLER_16_1024 VPWR VGND sg13g2_decap_4
XFILLER_10_922 VPWR VGND sg13g2_decap_8
XFILLER_21_270 VPWR VGND sg13g2_decap_4
XFILLER_21_281 VPWR VGND sg13g2_decap_8
XFILLER_6_904 VPWR VGND sg13g2_decap_8
XFILLER_5_447 VPWR VGND sg13g2_decap_8
XFILLER_10_999 VPWR VGND sg13g2_decap_8
XFILLER_1_664 VPWR VGND sg13g2_decap_8
XFILLER_49_635 VPWR VGND sg13g2_decap_8
XFILLER_0_185 VPWR VGND sg13g2_decap_8
XFILLER_48_156 VPWR VGND sg13g2_fill_2
XFILLER_37_819 VPWR VGND sg13g2_decap_8
XFILLER_45_830 VPWR VGND sg13g2_decap_8
Xu_ppwm_u_mem__1136__79 VPWR VGND net79 sg13g2_tiehi
XFILLER_17_510 VPWR VGND sg13g2_decap_8
Xu_ppwm_u_mem__1001_ net488 VPWR u_ppwm_u_mem__1001_/Y VGND hold209/A net390 sg13g2_o21ai_1
XFILLER_17_587 VPWR VGND sg13g2_decap_8
XFILLER_32_557 VPWR VGND sg13g2_decap_8
XFILLER_40_590 VPWR VGND sg13g2_decap_8
XFILLER_9_731 VPWR VGND sg13g2_decap_8
XFILLER_12_270 VPWR VGND sg13g2_decap_8
XFILLER_5_30 VPWR VGND sg13g2_fill_1
Xu_ppwm_u_mem__0716_ u_ppwm_u_mem__0831_/A net451 VPWR VGND sg13g2_inv_2
XFILLER_4_480 VPWR VGND sg13g2_decap_8
Xu_ppwm_u_mem__0647_ VPWR u_ppwm_u_mem__0647_/Y net565 VGND sg13g2_inv_1
XFILLER_10_0 VPWR VGND sg13g2_fill_2
XFILLER_28_819 VPWR VGND sg13g2_decap_8
XFILLER_39_145 VPWR VGND sg13g2_fill_2
XFILLER_27_329 VPWR VGND sg13g2_decap_4
XFILLER_36_830 VPWR VGND sg13g2_decap_8
XFILLER_35_373 VPWR VGND sg13g2_fill_2
XFILLER_23_546 VPWR VGND sg13g2_decap_8
XFILLER_35_384 VPWR VGND sg13g2_fill_2
XFILLER_10_207 VPWR VGND sg13g2_decap_8
XFILLER_10_229 VPWR VGND sg13g2_fill_2
Xhold241 hold241/A VPWR VGND net624 sg13g2_dlygate4sd3_1
Xhold230 hold230/A VPWR VGND net613 sg13g2_dlygate4sd3_1
XFILLER_2_417 VPWR VGND sg13g2_decap_8
Xhold252 hold252/A VPWR VGND net635 sg13g2_dlygate4sd3_1
XFILLER_49_14 VPWR VGND sg13g2_decap_8
XFILLER_46_1028 VPWR VGND sg13g2_fill_1
Xhold263 hold263/A VPWR VGND net646 sg13g2_dlygate4sd3_1
Xhold296 hold296/A VPWR VGND net679 sg13g2_dlygate4sd3_1
Xhold285 hold285/A VPWR VGND net668 sg13g2_dlygate4sd3_1
Xhold274 hold274/A VPWR VGND net657 sg13g2_dlygate4sd3_1
Xu_ppwm_u_pwm__241__217 VPWR VGND net217 sg13g2_tiehi
XFILLER_27_841 VPWR VGND sg13g2_decap_8
XFILLER_42_811 VPWR VGND sg13g2_decap_8
XFILLER_14_513 VPWR VGND sg13g2_decap_8
XFILLER_42_888 VPWR VGND sg13g2_decap_8
Xu_ppwm_u_pwm__240_ net197 VGND VPWR u_ppwm_u_pwm__240_/D hold241/A clknet_5_0__leaf_clk
+ sg13g2_dfrbpq_2
XFILLER_6_701 VPWR VGND sg13g2_decap_8
Xu_ppwm_u_pwm__171_ net628 u_ppwm_u_pwm__171_/C net593 u_ppwm_u_pwm__174_/B VPWR VGND
+ sg13g2_nand3_1
XFILLER_14_94 VPWR VGND sg13g2_decap_8
XFILLER_10_796 VPWR VGND sg13g2_decap_8
XFILLER_6_778 VPWR VGND sg13g2_decap_8
XFILLER_2_984 VPWR VGND sg13g2_decap_8
XFILLER_1_461 VPWR VGND sg13g2_decap_8
XFILLER_49_432 VPWR VGND sg13g2_decap_8
XFILLER_37_616 VPWR VGND sg13g2_decap_8
XFILLER_18_830 VPWR VGND sg13g2_decap_8
XFILLER_33_844 VPWR VGND sg13g2_decap_8
Xu_ppwm_u_ex__0984_ u_ppwm_u_ex__0985_/B net355 hold259/A net357 hold234/A VPWR VGND
+ sg13g2_a22oi_1
XFILLER_20_538 VPWR VGND sg13g2_decap_8
Xu_ppwm_u_mem__1158__135 VPWR VGND net135 sg13g2_tiehi
XFILLER_28_616 VPWR VGND sg13g2_decap_8
XFILLER_27_126 VPWR VGND sg13g2_fill_2
XFILLER_27_137 VPWR VGND sg13g2_fill_2
XFILLER_42_129 VPWR VGND sg13g2_decap_4
XFILLER_23_332 VPWR VGND sg13g2_fill_2
XFILLER_24_866 VPWR VGND sg13g2_decap_8
XFILLER_11_549 VPWR VGND sg13g2_decap_8
XFILLER_47_947 VPWR VGND sg13g2_decap_8
XFILLER_18_104 VPWR VGND sg13g2_decap_4
XFILLER_19_627 VPWR VGND sg13g2_decap_8
XFILLER_46_468 VPWR VGND sg13g2_decap_8
XFILLER_15_822 VPWR VGND sg13g2_decap_8
XFILLER_34_619 VPWR VGND sg13g2_decap_8
XFILLER_42_685 VPWR VGND sg13g2_decap_8
XFILLER_15_899 VPWR VGND sg13g2_decap_8
XFILLER_30_836 VPWR VGND sg13g2_decap_8
Xu_ppwm_u_mem__0981_ net483 VPWR u_ppwm_u_mem__0981_/Y VGND hold101/A net384 sg13g2_o21ai_1
Xclkbuf_4_6_0_clk clknet_0_clk clknet_4_6_0_clk VPWR VGND sg13g2_buf_8
Xu_ppwm_u_pwm__223_ u_ppwm_u_pwm__227_/C hold200/A u_ppwm_u_pwm__133_/Y hold241/A
+ u_ppwm_u_pwm__132_/Y VPWR VGND sg13g2_a22oi_1
Xu_ppwm_u_pwm__154_ net612 net596 u_ppwm_u_pwm__154_/A u_ppwm_u_pwm__160_/C VPWR VGND
+ net588 sg13g2_nand4_1
XFILLER_10_593 VPWR VGND sg13g2_decap_8
XFILLER_6_575 VPWR VGND sg13g2_decap_8
XFILLER_2_781 VPWR VGND sg13g2_decap_8
XFILLER_1_291 VPWR VGND sg13g2_fill_2
Xu_ppwm_u_global_counter__172_ net59 VGND VPWR u_ppwm_u_global_counter__172_/D hold246/A
+ clknet_5_20__leaf_clk sg13g2_dfrbpq_2
XFILLER_38_903 VPWR VGND sg13g2_decap_8
XFILLER_49_262 VPWR VGND sg13g2_fill_1
XFILLER_24_107 VPWR VGND sg13g2_fill_1
XFILLER_33_641 VPWR VGND sg13g2_decap_8
XFILLER_36_1005 VPWR VGND sg13g2_decap_8
XFILLER_20_302 VPWR VGND sg13g2_fill_2
XFILLER_20_324 VPWR VGND sg13g2_fill_2
Xu_ppwm_u_ex__0967_ u_ppwm_u_ex__0968_/B u_ppwm_u_ex__0898_/B u_ppwm_u_ex__0846_/A
+ u_ppwm_u_ex__0933_/B u_ppwm_u_ex__0801_/B VPWR VGND sg13g2_a22oi_1
XFILLER_21_869 VPWR VGND sg13g2_decap_8
Xu_ppwm_u_mem__1125__101 VPWR VGND net101 sg13g2_tiehi
Xu_ppwm_u_ex__0898_ net369 u_ppwm_u_ex__0898_/B u_ppwm_u_ex__0898_/Y VPWR VGND sg13g2_nor2_1
XFILLER_0_707 VPWR VGND sg13g2_decap_8
XFILLER_43_1009 VPWR VGND sg13g2_decap_8
XFILLER_29_969 VPWR VGND sg13g2_decap_8
XFILLER_37_980 VPWR VGND sg13g2_decap_8
XFILLER_24_663 VPWR VGND sg13g2_decap_8
XFILLER_12_814 VPWR VGND sg13g2_decap_8
XFILLER_8_829 VPWR VGND sg13g2_decap_8
XFILLER_23_184 VPWR VGND sg13g2_decap_8
XFILLER_23_195 VPWR VGND sg13g2_fill_2
XFILLER_7_317 VPWR VGND sg13g2_decap_4
XFILLER_3_567 VPWR VGND sg13g2_decap_8
XFILLER_19_413 VPWR VGND sg13g2_fill_1
Xfanout370 net371 net370 VPWR VGND sg13g2_buf_8
Xfanout381 net386 net381 VPWR VGND sg13g2_buf_8
Xfanout392 net393 net392 VPWR VGND sg13g2_buf_8
XFILLER_47_744 VPWR VGND sg13g2_decap_8
Xu_ppwm_u_mem__1180_ net161 VGND VPWR u_ppwm_u_mem__1180_/D hold162/A clknet_5_22__leaf_clk
+ sg13g2_dfrbpq_1
XFILLER_46_276 VPWR VGND sg13g2_fill_1
XFILLER_28_980 VPWR VGND sg13g2_decap_8
XFILLER_42_482 VPWR VGND sg13g2_decap_8
XFILLER_15_696 VPWR VGND sg13g2_decap_8
Xu_ppwm_u_ex__0821_ net372 net367 u_ppwm_u_ex__0821_/C u_ppwm_u_ex__0821_/Y VPWR VGND
+ sg13g2_nor3_1
XFILLER_30_633 VPWR VGND sg13g2_decap_8
Xu_ppwm_u_ex__0752_ net428 hold264/A u_ppwm_u_ex__0752_/Y VPWR VGND sg13g2_nor2b_1
Xu_ppwm_u_mem__0964_ VGND VPWR u_ppwm_u_mem__0650_/Y net382 u_ppwm_u_mem__1152_/D
+ u_ppwm_u_mem__0963_/Y sg13g2_a21oi_1
Xu_ppwm_u_pwm__206_ hold250/A hold195/A u_ppwm_u_pwm__214_/C VPWR VGND sg13g2_nor2b_1
Xu_ppwm_u_mem__0895_ net500 VPWR u_ppwm_u_mem__0895_/Y VGND hold181/A net401 sg13g2_o21ai_1
Xu_ppwm_u_ex__0683_ net448 net440 u_ppwm_u_ex__0683_/Y VPWR VGND sg13g2_nor2b_1
XFILLER_7_862 VPWR VGND sg13g2_decap_8
XFILLER_6_350 VPWR VGND sg13g2_fill_2
XFILLER_6_394 VPWR VGND sg13g2_fill_2
Xu_ppwm_u_pwm__137_ VPWR u_ppwm_u_pwm__137_/Y net223 VGND sg13g2_inv_1
Xu_ppwm_u_mem__1194__165 VPWR VGND net165 sg13g2_tiehi
XFILLER_38_700 VPWR VGND sg13g2_decap_8
Xu_ppwm_u_global_counter__155_ u_ppwm_u_global_counter__155_/A u_ppwm_u_global_counter__155_/B
+ u_ppwm_u_global_counter__155_/C u_ppwm_u_global_counter__156_/D VPWR VGND sg13g2_nor3_1
XFILLER_26_928 VPWR VGND sg13g2_decap_8
XFILLER_38_777 VPWR VGND sg13g2_decap_8
Xu_ppwm_u_ex__1097_ u_ppwm_u_ex__1097_/Y net348 net665 net359 net675 VPWR VGND sg13g2_a22oi_1
XFILLER_16_18 VPWR VGND sg13g2_decap_8
XFILLER_19_991 VPWR VGND sg13g2_decap_8
XFILLER_25_438 VPWR VGND sg13g2_decap_8
XFILLER_41_909 VPWR VGND sg13g2_decap_8
XFILLER_34_983 VPWR VGND sg13g2_decap_8
XFILLER_21_666 VPWR VGND sg13g2_decap_8
XFILLER_0_504 VPWR VGND sg13g2_decap_8
XFILLER_29_766 VPWR VGND sg13g2_decap_8
XFILLER_44_747 VPWR VGND sg13g2_decap_8
XFILLER_43_257 VPWR VGND sg13g2_decap_8
XFILLER_12_611 VPWR VGND sg13g2_decap_8
XFILLER_24_460 VPWR VGND sg13g2_decap_8
XFILLER_40_975 VPWR VGND sg13g2_decap_8
XFILLER_8_626 VPWR VGND sg13g2_decap_8
XFILLER_12_688 VPWR VGND sg13g2_decap_8
XFILLER_11_176 VPWR VGND sg13g2_decap_8
Xu_ppwm_u_mem__0680_ VPWR u_ppwm_u_mem__0680_/Y net227 VGND sg13g2_inv_1
XFILLER_4_865 VPWR VGND sg13g2_decap_8
XFILLER_26_1026 VPWR VGND sg13g2_fill_2
XFILLER_47_541 VPWR VGND sg13g2_decap_8
Xu_ppwm_u_ex__1020_ u_ppwm_u_ex__1020_/Y net446 fanout359/A VPWR VGND sg13g2_nand2_1
Xu_ppwm_u_mem__1163_ net116 VGND VPWR net253 hold35/A clknet_5_13__leaf_clk sg13g2_dfrbpq_1
XFILLER_16_961 VPWR VGND sg13g2_decap_8
XFILLER_35_758 VPWR VGND sg13g2_decap_8
Xu_ppwm_u_mem__1094_ net162 VGND VPWR net333 hold115/A clknet_5_11__leaf_clk sg13g2_dfrbpq_1
XFILLER_15_493 VPWR VGND sg13g2_decap_8
XFILLER_31_964 VPWR VGND sg13g2_decap_8
XFILLER_33_1019 VPWR VGND sg13g2_decap_8
XFILLER_8_52 VPWR VGND sg13g2_fill_2
Xu_ppwm_u_ex__0804_ net372 net365 u_ppwm_u_ex__0804_/C u_ppwm_u_ex__0804_/Y VPWR VGND
+ sg13g2_nor3_2
Xu_ppwm_u_ex__0735_ VPWR VGND u_ppwm_u_ex__0733_/Y u_ppwm_u_ex__0734_/Y u_ppwm_u_ex__0732_/Y
+ net438 u_ppwm_u_ex__0735_/Y u_ppwm_u_ex__0599_/Y sg13g2_a221oi_1
Xu_ppwm_u_mem__0947_ net487 VPWR u_ppwm_u_mem__0947_/Y VGND net243 net387 sg13g2_o21ai_1
Xu_ppwm_u_mem__0878_ VGND VPWR u_ppwm_u_mem__0693_/Y net399 u_ppwm_u_mem__1109_/D
+ u_ppwm_u_mem__0877_/Y sg13g2_a21oi_1
Xu_ppwm_u_ex__0666_ net442 hold291/A u_ppwm_u_ex__0666_/Y VPWR VGND sg13g2_nor2b_1
XFILLER_40_0 VPWR VGND sg13g2_decap_8
Xu_ppwm_u_ex__0597_ VPWR u_ppwm_u_ex__0597_/Y net423 VGND sg13g2_inv_1
XFILLER_38_574 VPWR VGND sg13g2_decap_8
Xu_ppwm_u_global_counter__138_ hold247/A net629 u_ppwm_u_global_counter__138_/B VPWR
+ VGND sg13g2_xnor2_1
XFILLER_26_725 VPWR VGND sg13g2_decap_8
XFILLER_41_706 VPWR VGND sg13g2_decap_8
XFILLER_34_780 VPWR VGND sg13g2_decap_8
XFILLER_22_931 VPWR VGND sg13g2_decap_8
XFILLER_5_629 VPWR VGND sg13g2_decap_8
XFILLER_1_846 VPWR VGND sg13g2_decap_8
XFILLER_49_817 VPWR VGND sg13g2_decap_8
XFILLER_0_378 VPWR VGND sg13g2_decap_8
XFILLER_48_349 VPWR VGND sg13g2_decap_8
Xclkbuf_5_26__f_clk clknet_4_13_0_clk clknet_5_26__leaf_clk VPWR VGND sg13g2_buf_8
XFILLER_29_563 VPWR VGND sg13g2_decap_8
XFILLER_1_1028 VPWR VGND sg13g2_fill_1
XFILLER_44_544 VPWR VGND sg13g2_decap_8
XFILLER_16_246 VPWR VGND sg13g2_fill_2
XFILLER_17_769 VPWR VGND sg13g2_decap_8
XFILLER_32_739 VPWR VGND sg13g2_decap_8
XFILLER_13_931 VPWR VGND sg13g2_decap_8
XFILLER_40_772 VPWR VGND sg13g2_decap_8
Xu_ppwm_u_pwm__251__208 VPWR VGND net208 sg13g2_tiehi
XFILLER_9_913 VPWR VGND sg13g2_decap_8
XFILLER_12_485 VPWR VGND sg13g2_decap_8
Xu_ppwm_u_mem__0801_ hold180/A net466 u_ppwm_u_mem__0801_/Y VPWR VGND sg13g2_nor2b_1
Xu_ppwm_u_mem__0732_ hold100/A hold83/A net473 u_ppwm_u_mem__0732_/X VPWR VGND sg13g2_mux2_1
XFILLER_4_662 VPWR VGND sg13g2_decap_8
Xu_ppwm_u_mem__0663_ VPWR u_ppwm_u_mem__0663_/Y net265 VGND sg13g2_inv_1
XFILLER_3_172 VPWR VGND sg13g2_fill_2
XFILLER_12_4 VPWR VGND sg13g2_decap_4
Xhold1 hold1/A VPWR VGND net218 sg13g2_dlygate4sd3_1
Xu_ppwm_u_ex__1003_ u_ppwm_u_ex__1003_/Y fanout348/A hold216/A net359 net448 VPWR
+ VGND sg13g2_a22oi_1
Xu_ppwm_u_mem__1146_ net178 VGND VPWR u_ppwm_u_mem__1146_/D hold174/A clknet_5_8__leaf_clk
+ sg13g2_dfrbpq_1
XFILLER_35_555 VPWR VGND sg13g2_decap_8
Xu_ppwm_u_mem__1077_ u_ppwm_u_mem__1076_/Y net631 u_ppwm_u_mem__1077_/S hold249/A
+ VPWR VGND sg13g2_mux2_1
XFILLER_23_728 VPWR VGND sg13g2_decap_8
XFILLER_13_19 VPWR VGND sg13g2_fill_2
XFILLER_31_761 VPWR VGND sg13g2_decap_8
XFILLER_8_990 VPWR VGND sg13g2_decap_8
Xu_ppwm_u_ex__0718_ u_ppwm_u_ex__0717_/Y VPWR u_ppwm_u_ex__0718_/Y VGND hold297/A
+ u_ppwm_u_ex__0596_/Y sg13g2_o21ai_1
XFILLER_1_109 VPWR VGND sg13g2_decap_8
Xu_ppwm_u_ex__0649_ VGND VPWR u_ppwm_u_ex__0648_/A u_ppwm_u_ex__0648_/B u_ppwm_u_ex__0650_/B
+ u_ppwm_u_ex__0648_/C sg13g2_a21oi_1
XFILLER_38_16 VPWR VGND sg13g2_fill_1
XFILLER_39_850 VPWR VGND sg13g2_decap_8
XFILLER_26_522 VPWR VGND sg13g2_decap_8
XFILLER_38_382 VPWR VGND sg13g2_decap_8
XFILLER_38_393 VPWR VGND sg13g2_fill_2
XFILLER_41_503 VPWR VGND sg13g2_decap_8
XFILLER_26_599 VPWR VGND sg13g2_decap_8
XFILLER_13_249 VPWR VGND sg13g2_fill_2
XFILLER_10_901 VPWR VGND sg13g2_decap_8
XFILLER_16_1003 VPWR VGND sg13g2_decap_8
XFILLER_10_978 VPWR VGND sg13g2_decap_8
XFILLER_5_426 VPWR VGND sg13g2_decap_8
Xu_ppwm_u_mem__1144__181 VPWR VGND net181 sg13g2_tiehi
XFILLER_1_643 VPWR VGND sg13g2_decap_8
XFILLER_49_614 VPWR VGND sg13g2_decap_8
XFILLER_0_164 VPWR VGND sg13g2_decap_8
XFILLER_29_360 VPWR VGND sg13g2_decap_8
Xu_ppwm_u_mem__1151__163 VPWR VGND net163 sg13g2_tiehi
Xu_ppwm_u_mem__1000_ VGND VPWR u_ppwm_u_mem__0632_/Y net389 hold52/A u_ppwm_u_mem__0999_/Y
+ sg13g2_a21oi_1
XFILLER_45_886 VPWR VGND sg13g2_decap_8
XFILLER_44_374 VPWR VGND sg13g2_fill_2
XFILLER_17_566 VPWR VGND sg13g2_decap_8
XFILLER_32_536 VPWR VGND sg13g2_decap_8
XFILLER_9_710 VPWR VGND sg13g2_decap_8
XFILLER_9_787 VPWR VGND sg13g2_decap_8
XFILLER_5_993 VPWR VGND sg13g2_decap_8
Xu_ppwm_u_mem__0715_ VPWR u_ppwm_u_mem__0833_/B net220 VGND sg13g2_inv_1
Xu_ppwm_u_mem__0646_ VPWR u_ppwm_u_mem__0646_/Y net531 VGND sg13g2_inv_1
XFILLER_35_341 VPWR VGND sg13g2_fill_1
Xu_ppwm_u_mem__1129_ net93 VGND VPWR u_ppwm_u_mem__1129_/D hold175/A clknet_5_31__leaf_clk
+ sg13g2_dfrbpq_2
XFILLER_39_1025 VPWR VGND sg13g2_decap_4
XFILLER_36_886 VPWR VGND sg13g2_decap_8
XFILLER_23_525 VPWR VGND sg13g2_decap_8
Xhold220 hold220/A VPWR VGND net603 sg13g2_dlygate4sd3_1
Xhold242 hold242/A VPWR VGND net625 sg13g2_dlygate4sd3_1
Xhold231 hold231/A VPWR VGND net614 sg13g2_dlygate4sd3_1
Xhold253 hold253/A VPWR VGND net636 sg13g2_dlygate4sd3_1
XFILLER_46_1007 VPWR VGND sg13g2_decap_8
Xhold275 hold275/A VPWR VGND net658 sg13g2_dlygate4sd3_1
Xhold264 hold264/A VPWR VGND net647 sg13g2_dlygate4sd3_1
Xhold286 hold286/A VPWR VGND net669 sg13g2_dlygate4sd3_1
Xhold297 hold297/A VPWR VGND net680 sg13g2_dlygate4sd3_1
XFILLER_19_809 VPWR VGND sg13g2_decap_8
XFILLER_27_820 VPWR VGND sg13g2_decap_8
XFILLER_26_330 VPWR VGND sg13g2_fill_2
XFILLER_27_897 VPWR VGND sg13g2_decap_8
XFILLER_42_867 VPWR VGND sg13g2_decap_8
XFILLER_14_569 VPWR VGND sg13g2_decap_8
Xu_ppwm_u_pwm__170_ VGND VPWR hold245/A u_ppwm_u_pwm__171_/C hold211/A net593 sg13g2_a21oi_1
XFILLER_10_775 VPWR VGND sg13g2_decap_8
XFILLER_6_757 VPWR VGND sg13g2_decap_8
XFILLER_2_963 VPWR VGND sg13g2_decap_8
XFILLER_1_440 VPWR VGND sg13g2_decap_8
XFILLER_49_411 VPWR VGND sg13g2_decap_8
XFILLER_7_1023 VPWR VGND sg13g2_decap_4
XFILLER_49_488 VPWR VGND sg13g2_decap_8
XFILLER_18_886 VPWR VGND sg13g2_decap_8
XFILLER_33_823 VPWR VGND sg13g2_decap_8
XFILLER_45_683 VPWR VGND sg13g2_decap_8
XFILLER_32_344 VPWR VGND sg13g2_decap_8
XFILLER_32_355 VPWR VGND sg13g2_fill_2
Xu_ppwm_u_ex__0983_ u_ppwm_u_ex__0987_/B u_ppwm_u_ex__0983_/A u_ppwm_u_ex__0983_/B
+ VPWR VGND sg13g2_nand2_1
XFILLER_20_517 VPWR VGND sg13g2_decap_8
XFILLER_9_584 VPWR VGND sg13g2_decap_8
XFILLER_5_790 VPWR VGND sg13g2_decap_8
Xu_ppwm_u_mem__0629_ VPWR u_ppwm_u_mem__0629_/Y net339 VGND sg13g2_inv_1
XFILLER_27_105 VPWR VGND sg13g2_decap_4
XFILLER_24_845 VPWR VGND sg13g2_decap_8
XFILLER_35_182 VPWR VGND sg13g2_fill_1
XFILLER_36_683 VPWR VGND sg13g2_decap_8
XFILLER_23_355 VPWR VGND sg13g2_decap_8
XFILLER_23_366 VPWR VGND sg13g2_fill_1
XFILLER_11_528 VPWR VGND sg13g2_decap_8
XFILLER_23_377 VPWR VGND sg13g2_fill_1
XFILLER_3_749 VPWR VGND sg13g2_decap_8
Xu_ppwm_u_mem__1102__146 VPWR VGND net146 sg13g2_tiehi
XFILLER_19_606 VPWR VGND sg13g2_decap_8
XFILLER_47_926 VPWR VGND sg13g2_decap_8
XFILLER_18_116 VPWR VGND sg13g2_fill_2
XFILLER_46_447 VPWR VGND sg13g2_decap_8
XFILLER_15_801 VPWR VGND sg13g2_decap_8
XFILLER_33_108 VPWR VGND sg13g2_decap_4
XFILLER_27_694 VPWR VGND sg13g2_decap_8
XFILLER_42_664 VPWR VGND sg13g2_decap_8
XFILLER_14_333 VPWR VGND sg13g2_fill_1
XFILLER_15_878 VPWR VGND sg13g2_decap_8
XFILLER_25_61 VPWR VGND sg13g2_decap_4
XFILLER_14_366 VPWR VGND sg13g2_fill_1
XFILLER_14_399 VPWR VGND sg13g2_fill_1
XFILLER_30_815 VPWR VGND sg13g2_decap_8
Xu_ppwm_u_pwm__222_ u_ppwm_u_pwm__222_/A u_ppwm_u_pwm__222_/B u_ppwm_u_pwm__222_/C
+ u_ppwm_u_pwm__222_/D u_ppwm_u_pwm__226_/A VPWR VGND sg13g2_and4_1
Xu_ppwm_u_mem__0980_ VGND VPWR u_ppwm_u_mem__0642_/Y net381 u_ppwm_u_mem__1160_/D
+ u_ppwm_u_mem__0979_/Y sg13g2_a21oi_1
XFILLER_10_572 VPWR VGND sg13g2_decap_8
XFILLER_6_554 VPWR VGND sg13g2_decap_8
Xu_ppwm_u_pwm__153_ net612 u_ppwm_u_pwm__151_/B hold230/A VPWR VGND sg13g2_nor2b_1
XFILLER_44_7 VPWR VGND sg13g2_decap_4
XFILLER_2_760 VPWR VGND sg13g2_decap_8
Xu_ppwm_u_global_counter__171_ net63 VGND VPWR u_ppwm_u_global_counter__171_/D hold296/A
+ clknet_5_20__leaf_clk sg13g2_dfrbpq_2
XFILLER_2_32 VPWR VGND sg13g2_decap_4
XFILLER_38_959 VPWR VGND sg13g2_decap_8
XFILLER_45_480 VPWR VGND sg13g2_decap_8
XFILLER_17_171 VPWR VGND sg13g2_decap_4
XFILLER_18_683 VPWR VGND sg13g2_decap_8
XFILLER_33_620 VPWR VGND sg13g2_decap_8
XFILLER_33_697 VPWR VGND sg13g2_decap_8
XFILLER_36_1028 VPWR VGND sg13g2_fill_1
Xu_ppwm_u_ex__0966_ u_ppwm_u_ex__0968_/A u_ppwm_u_ex__0966_/A u_ppwm_u_ex__0966_/B
+ VPWR VGND sg13g2_nand2_1
XFILLER_21_848 VPWR VGND sg13g2_decap_8
XFILLER_32_196 VPWR VGND sg13g2_decap_8
Xu_ppwm_u_ex__0897_ u_ppwm_u_ex__0896_/Y VPWR u_ppwm_u_ex__0897_/Y VGND net431 u_ppwm_u_ex__0896_/B
+ sg13g2_o21ai_1
Xclkbuf_5_7__f_clk clknet_4_3_0_clk clknet_5_7__leaf_clk VPWR VGND sg13g2_buf_8
XFILLER_28_414 VPWR VGND sg13g2_fill_1
XFILLER_29_948 VPWR VGND sg13g2_decap_8
XFILLER_44_929 VPWR VGND sg13g2_decap_8
XFILLER_28_469 VPWR VGND sg13g2_decap_8
XFILLER_36_480 VPWR VGND sg13g2_decap_8
XFILLER_24_642 VPWR VGND sg13g2_decap_8
XFILLER_8_808 VPWR VGND sg13g2_decap_8
XFILLER_20_881 VPWR VGND sg13g2_decap_8
XFILLER_3_546 VPWR VGND sg13g2_decap_8
Xu_ppwm_u_pwm__247__202 VPWR VGND net202 sg13g2_tiehi
XFILLER_47_723 VPWR VGND sg13g2_decap_8
Xfanout393 net397 net393 VPWR VGND sg13g2_buf_8
Xfanout360 fanout361/A net360 VPWR VGND sg13g2_buf_8
Xfanout382 net386 net382 VPWR VGND sg13g2_buf_2
Xfanout371 fanout371/A net371 VPWR VGND sg13g2_buf_8
XFILLER_4_1026 VPWR VGND sg13g2_fill_2
XFILLER_46_255 VPWR VGND sg13g2_decap_8
XFILLER_34_439 VPWR VGND sg13g2_fill_2
XFILLER_27_491 VPWR VGND sg13g2_decap_8
XFILLER_43_995 VPWR VGND sg13g2_decap_8
XFILLER_42_461 VPWR VGND sg13g2_decap_8
XFILLER_14_152 VPWR VGND sg13g2_fill_2
XFILLER_15_675 VPWR VGND sg13g2_decap_8
XFILLER_30_612 VPWR VGND sg13g2_decap_8
Xu_ppwm_u_ex__0820_ u_ppwm_u_ex__0799_/X net370 u_ppwm_u_ex__0819_/Y u_ppwm_u_ex__0821_/C
+ VPWR VGND sg13g2_a21o_1
Xu_ppwm_u_ex__0751_ net438 u_ppwm_u_ex__0751_/B u_ppwm_u_ex__0751_/Y VPWR VGND sg13g2_nor2_1
Xu_ppwm_u_mem__0963_ net483 VPWR u_ppwm_u_mem__0963_/Y VGND net231 net382 sg13g2_o21ai_1
XFILLER_30_689 VPWR VGND sg13g2_decap_8
XFILLER_7_841 VPWR VGND sg13g2_decap_8
Xu_ppwm_u_pwm__205_ hold195/A hold250/A u_ppwm_u_pwm__214_/B VPWR VGND sg13g2_nor2b_1
XFILLER_11_892 VPWR VGND sg13g2_decap_8
Xu_ppwm_u_mem__0894_ VGND VPWR u_ppwm_u_mem__0685_/Y net401 u_ppwm_u_mem__1117_/D
+ u_ppwm_u_mem__0893_/Y sg13g2_a21oi_1
Xu_ppwm_u_ex__0682_ net450 hold264/A u_ppwm_u_ex__0682_/Y VPWR VGND sg13g2_nor2b_1
Xu_ppwm_u_pwm__136_ VPWR u_ppwm_u_pwm__136_/Y net552 VGND sg13g2_inv_1
XFILLER_42_1021 VPWR VGND sg13g2_decap_8
Xu_ppwm_u_global_counter__154_ u_ppwm_u_global_counter__155_/A VPWR u_ppwm_u_global_counter__157_/B
+ VGND u_ppwm_u_global_counter__155_/B u_ppwm_u_global_counter__150_/B sg13g2_o21ai_1
XFILLER_38_756 VPWR VGND sg13g2_decap_8
XFILLER_19_970 VPWR VGND sg13g2_decap_8
XFILLER_26_907 VPWR VGND sg13g2_decap_8
Xu_ppwm_u_ex__1096_ u_ppwm_u_ex__1096_/Y net664 net347 VPWR VGND sg13g2_nand2_1
XFILLER_25_417 VPWR VGND sg13g2_fill_1
XFILLER_34_962 VPWR VGND sg13g2_decap_8
XFILLER_33_461 VPWR VGND sg13g2_fill_1
XFILLER_20_100 VPWR VGND sg13g2_fill_2
XFILLER_20_111 VPWR VGND sg13g2_decap_8
XFILLER_21_645 VPWR VGND sg13g2_decap_8
XFILLER_33_494 VPWR VGND sg13g2_decap_8
Xu_ppwm_u_ex__0949_ u_ppwm_u_ex__0948_/Y VPWR u_ppwm_u_ex__0949_/Y VGND u_ppwm_u_ex__0799_/X
+ u_ppwm_u_ex__0847_/B sg13g2_o21ai_1
Xu_ppwm_u_global_counter__161__64 VPWR VGND net64 sg13g2_tiehi
Xclkbuf_4_5_0_clk clknet_0_clk clknet_4_5_0_clk VPWR VGND sg13g2_buf_8
XFILLER_28_222 VPWR VGND sg13g2_fill_1
XFILLER_29_745 VPWR VGND sg13g2_decap_8
XFILLER_44_726 VPWR VGND sg13g2_decap_8
XFILLER_19_1012 VPWR VGND sg13g2_decap_8
XFILLER_25_984 VPWR VGND sg13g2_decap_8
XFILLER_40_954 VPWR VGND sg13g2_decap_8
XFILLER_8_605 VPWR VGND sg13g2_decap_8
XFILLER_12_667 VPWR VGND sg13g2_decap_8
XFILLER_7_159 VPWR VGND sg13g2_fill_1
XFILLER_4_844 VPWR VGND sg13g2_decap_8
XFILLER_3_343 VPWR VGND sg13g2_fill_2
XFILLER_0_0 VPWR VGND sg13g2_decap_8
XFILLER_26_1005 VPWR VGND sg13g2_decap_8
XFILLER_47_520 VPWR VGND sg13g2_decap_8
XFILLER_19_200 VPWR VGND sg13g2_decap_8
XFILLER_19_211 VPWR VGND sg13g2_fill_2
Xu_ppwm_u_mem__1162_ net120 VGND VPWR u_ppwm_u_mem__1162_/D hold101/A clknet_5_8__leaf_clk
+ sg13g2_dfrbpq_1
XFILLER_47_597 VPWR VGND sg13g2_decap_8
XFILLER_35_737 VPWR VGND sg13g2_decap_8
XFILLER_16_940 VPWR VGND sg13g2_decap_8
Xu_ppwm_u_mem__1093_ net164 VGND VPWR net306 hold88/A clknet_5_11__leaf_clk sg13g2_dfrbpq_1
XFILLER_15_450 VPWR VGND sg13g2_decap_8
XFILLER_43_792 VPWR VGND sg13g2_decap_8
XFILLER_31_943 VPWR VGND sg13g2_decap_8
XFILLER_8_31 VPWR VGND sg13g2_fill_2
Xu_ppwm_u_ex__0803_ u_ppwm_u_ex__0803_/A u_ppwm_u_ex__0803_/B u_ppwm_u_ex__0803_/X
+ VPWR VGND sg13g2_and2_1
XFILLER_30_486 VPWR VGND sg13g2_decap_8
Xu_ppwm_u_ex__0734_ hold296/A net440 u_ppwm_u_ex__0734_/Y VPWR VGND sg13g2_nor2b_1
Xu_ppwm_u_mem__0946_ VGND VPWR u_ppwm_u_mem__0659_/Y net390 u_ppwm_u_mem__1143_/D
+ u_ppwm_u_mem__0945_/Y sg13g2_a21oi_1
Xu_ppwm_u_mem__0877_ net490 VPWR u_ppwm_u_mem__0877_/Y VGND net245 net399 sg13g2_o21ai_1
Xu_ppwm_u_ex__0665_ u_ppwm_u_ex__0665_/Y u_ppwm_u_ex__0656_/Y u_ppwm_u_ex__0664_/Y
+ net426 u_ppwm_u_ex__0715_/A VPWR VGND sg13g2_a22oi_1
Xu_ppwm_u_ex__0596_ VPWR u_ppwm_u_ex__0596_/Y hold256/A VGND sg13g2_inv_1
XFILLER_33_0 VPWR VGND sg13g2_decap_8
Xu_ppwm_u_global_counter__137_ u_ppwm_u_global_counter__138_/B u_ppwm_u_global_counter__136_/Y
+ u_ppwm_u_global_counter__171_/D VPWR VGND sg13g2_nor2b_1
XFILLER_26_704 VPWR VGND sg13g2_decap_8
XFILLER_38_553 VPWR VGND sg13g2_decap_8
Xu_ppwm_u_ex__1079_ u_ppwm_u_ex__1079_/B u_ppwm_u_ex__1079_/C net350 u_ppwm_u_ex__1079_/Y
+ VPWR VGND sg13g2_nand3_1
XFILLER_22_910 VPWR VGND sg13g2_decap_8
XFILLER_22_987 VPWR VGND sg13g2_decap_8
XFILLER_5_608 VPWR VGND sg13g2_decap_8
XFILLER_49_1027 VPWR VGND sg13g2_fill_2
XFILLER_1_825 VPWR VGND sg13g2_decap_8
XFILLER_0_357 VPWR VGND sg13g2_decap_8
XFILLER_1_1007 VPWR VGND sg13g2_decap_8
XFILLER_29_542 VPWR VGND sg13g2_decap_8
XFILLER_44_523 VPWR VGND sg13g2_decap_8
XFILLER_16_214 VPWR VGND sg13g2_fill_2
XFILLER_16_236 VPWR VGND sg13g2_fill_2
XFILLER_17_748 VPWR VGND sg13g2_decap_8
XFILLER_13_910 VPWR VGND sg13g2_decap_8
XFILLER_32_718 VPWR VGND sg13g2_decap_8
XFILLER_25_781 VPWR VGND sg13g2_decap_8
XFILLER_40_751 VPWR VGND sg13g2_decap_8
XFILLER_12_464 VPWR VGND sg13g2_decap_8
XFILLER_13_987 VPWR VGND sg13g2_decap_8
XFILLER_9_969 VPWR VGND sg13g2_decap_8
XFILLER_8_479 VPWR VGND sg13g2_decap_8
Xu_ppwm_u_mem__0800_ u_ppwm_u_mem__0799_/Y VPWR fanout374/A VGND u_ppwm_u_mem__0792_/Y
+ u_ppwm_u_mem__0793_/Y sg13g2_o21ai_1
Xu_ppwm_u_mem__0731_ hold4/A hold118/A net464 u_ppwm_u_mem__0731_/X VPWR VGND sg13g2_mux2_1
Xu_ppwm_u_mem__0662_ VPWR u_ppwm_u_mem__0662_/Y net251 VGND sg13g2_inv_1
XFILLER_4_641 VPWR VGND sg13g2_decap_8
Xhold2 hold2/A VPWR VGND net219 sg13g2_dlygate4sd3_1
Xu_ppwm_u_ex__1002_ u_ppwm_u_ex__1002_/Y net679 fanout347/A VPWR VGND sg13g2_nand2_1
XFILLER_48_884 VPWR VGND sg13g2_decap_8
Xu_ppwm_u_mem__1145_ net180 VGND VPWR net244 hold26/A clknet_5_9__leaf_clk sg13g2_dfrbpq_1
XFILLER_35_534 VPWR VGND sg13g2_decap_8
Xu_ppwm_u_mem__1076_ net631 VPWR u_ppwm_u_mem__1076_/Y VGND net610 u_ppwm_u_mem__1075_/B
+ sg13g2_o21ai_1
XFILLER_23_707 VPWR VGND sg13g2_decap_8
Xu_ppwm_u_ex__1119__37 VPWR VGND net37 sg13g2_tiehi
XFILLER_31_740 VPWR VGND sg13g2_decap_8
XFILLER_30_272 VPWR VGND sg13g2_fill_2
Xu_ppwm_u_mem__0929_ net502 VPWR u_ppwm_u_mem__0929_/Y VGND hold164/A net412 sg13g2_o21ai_1
Xu_ppwm_u_ex__0717_ u_ppwm_u_ex__0717_/Y u_ppwm_u_ex__0721_/A hold254/A VPWR VGND
+ sg13g2_nand2_1
Xu_ppwm_u_ex__0648_ u_ppwm_u_ex__0648_/B u_ppwm_u_ex__0648_/C u_ppwm_u_ex__0648_/A
+ u_ppwm_u_ex__0648_/Y VPWR VGND sg13g2_nand3_1
Xu_ppwm_u_ex__0579_ VPWR u_ppwm_u_ex__0925_/A net442 VGND sg13g2_inv_1
XFILLER_26_501 VPWR VGND sg13g2_decap_8
XFILLER_26_578 VPWR VGND sg13g2_decap_8
XFILLER_13_239 VPWR VGND sg13g2_fill_1
XFILLER_41_559 VPWR VGND sg13g2_decap_8
XFILLER_22_784 VPWR VGND sg13g2_decap_8
XFILLER_10_957 VPWR VGND sg13g2_decap_8
XFILLER_6_939 VPWR VGND sg13g2_decap_8
XFILLER_5_405 VPWR VGND sg13g2_decap_8
XFILLER_1_622 VPWR VGND sg13g2_decap_8
XFILLER_0_143 VPWR VGND sg13g2_decap_8
XFILLER_1_699 VPWR VGND sg13g2_decap_8
XFILLER_23_1008 VPWR VGND sg13g2_decap_8
XFILLER_45_865 VPWR VGND sg13g2_decap_8
XFILLER_17_545 VPWR VGND sg13g2_decap_8
Xu_ppwm_u_mem__1112__126 VPWR VGND net126 sg13g2_tiehi
XFILLER_32_515 VPWR VGND sg13g2_decap_8
XFILLER_13_784 VPWR VGND sg13g2_decap_8
XFILLER_9_766 VPWR VGND sg13g2_decap_8
XFILLER_8_287 VPWR VGND sg13g2_fill_1
XFILLER_8_276 VPWR VGND sg13g2_fill_1
Xu_ppwm_u_mem__0714_ VPWR u_ppwm_u_mem__0714_/Y net221 VGND sg13g2_inv_1
XFILLER_5_972 VPWR VGND sg13g2_decap_8
Xu_ppwm_u_mem__0645_ VPWR u_ppwm_u_mem__0645_/Y net319 VGND sg13g2_inv_1
XFILLER_10_2 VPWR VGND sg13g2_fill_1
XFILLER_48_681 VPWR VGND sg13g2_decap_8
Xu_ppwm_u_mem__1135__81 VPWR VGND net81 sg13g2_tiehi
Xu_ppwm_u_mem__1128_ net95 VGND VPWR net534 hold150/A clknet_5_27__leaf_clk sg13g2_dfrbpq_1
XFILLER_39_1004 VPWR VGND sg13g2_decap_8
XFILLER_23_504 VPWR VGND sg13g2_decap_8
XFILLER_36_865 VPWR VGND sg13g2_decap_8
XFILLER_35_386 VPWR VGND sg13g2_fill_1
Xu_ppwm_u_mem__1059_ net220 u_ppwm_u_mem__1209_/Q u_ppwm_u_mem__1075_/B VPWR VGND
+ u_ppwm_u_mem__1212_/Q sg13g2_nand3b_1
Xhold210 hold210/A VPWR VGND net593 sg13g2_dlygate4sd3_1
Xhold232 hold232/A VPWR VGND net615 sg13g2_dlygate4sd3_1
Xhold243 hold243/A VPWR VGND net626 sg13g2_dlygate4sd3_1
Xhold221 hold221/A VPWR VGND net604 sg13g2_dlygate4sd3_1
Xhold254 hold254/A VPWR VGND net637 sg13g2_dlygate4sd3_1
Xhold276 hold276/A VPWR VGND net659 sg13g2_dlygate4sd3_1
Xhold287 hold287/A VPWR VGND net670 sg13g2_dlygate4sd3_1
Xhold265 hold265/A VPWR VGND net648 sg13g2_dlygate4sd3_1
Xhold298 hold298/A VPWR VGND net681 sg13g2_dlygate4sd3_1
XFILLER_46_629 VPWR VGND sg13g2_decap_8
XFILLER_18_309 VPWR VGND sg13g2_decap_4
XFILLER_26_320 VPWR VGND sg13g2_decap_4
XFILLER_27_876 VPWR VGND sg13g2_decap_8
XFILLER_42_846 VPWR VGND sg13g2_decap_8
XFILLER_14_548 VPWR VGND sg13g2_decap_8
XFILLER_10_754 VPWR VGND sg13g2_decap_8
XFILLER_22_581 VPWR VGND sg13g2_decap_8
XFILLER_6_736 VPWR VGND sg13g2_decap_8
XFILLER_2_942 VPWR VGND sg13g2_decap_8
XFILLER_7_1002 VPWR VGND sg13g2_decap_8
XFILLER_49_467 VPWR VGND sg13g2_decap_8
XFILLER_1_496 VPWR VGND sg13g2_decap_8
XFILLER_17_320 VPWR VGND sg13g2_fill_2
XFILLER_45_662 VPWR VGND sg13g2_decap_8
XFILLER_17_353 VPWR VGND sg13g2_decap_8
XFILLER_18_865 VPWR VGND sg13g2_decap_8
XFILLER_33_802 VPWR VGND sg13g2_decap_8
Xu_ppwm_u_ex__0982_ u_ppwm_u_ex__0981_/Y VPWR u_ppwm_u_ex__0983_/B VGND u_ppwm_u_ex__0873_/A
+ u_ppwm_u_ex__0897_/Y sg13g2_o21ai_1
XFILLER_33_879 VPWR VGND sg13g2_decap_8
XFILLER_13_581 VPWR VGND sg13g2_decap_8
XFILLER_9_563 VPWR VGND sg13g2_decap_8
Xu_ppwm_u_mem__0628_ VPWR u_ppwm_u_mem__0628_/Y net551 VGND sg13g2_inv_1
XFILLER_35_18 VPWR VGND sg13g2_decap_8
XFILLER_36_662 VPWR VGND sg13g2_decap_8
XFILLER_23_301 VPWR VGND sg13g2_fill_2
XFILLER_24_824 VPWR VGND sg13g2_decap_8
XFILLER_11_507 VPWR VGND sg13g2_decap_8
Xu_ppwm_u_mem__1165__108 VPWR VGND net108 sg13g2_tiehi
XFILLER_3_728 VPWR VGND sg13g2_decap_8
XFILLER_47_905 VPWR VGND sg13g2_decap_8
XFILLER_27_673 VPWR VGND sg13g2_decap_8
XFILLER_42_643 VPWR VGND sg13g2_decap_8
XFILLER_41_120 VPWR VGND sg13g2_fill_2
XFILLER_15_857 VPWR VGND sg13g2_decap_8
XFILLER_41_186 VPWR VGND sg13g2_fill_1
Xu_ppwm_u_pwm__221_ u_ppwm_u_pwm__227_/B u_ppwm_u_pwm__222_/C u_ppwm_u_pwm__222_/D
+ VPWR VGND sg13g2_nand2_1
XFILLER_10_551 VPWR VGND sg13g2_decap_8
XFILLER_6_533 VPWR VGND sg13g2_decap_8
Xu_ppwm_u_pwm__152_ net597 u_ppwm_u_pwm__152_/B hold215/A VPWR VGND sg13g2_nor2_1
XFILLER_29_1025 VPWR VGND sg13g2_decap_4
XFILLER_37_7 VPWR VGND sg13g2_decap_8
Xu_ppwm_u_global_counter__170_ net66 VGND VPWR net609 hold225/A clknet_5_16__leaf_clk
+ sg13g2_dfrbpq_2
XFILLER_2_11 VPWR VGND sg13g2_decap_8
XFILLER_38_938 VPWR VGND sg13g2_decap_8
XFILLER_18_662 VPWR VGND sg13g2_decap_8
XFILLER_46_993 VPWR VGND sg13g2_decap_8
XFILLER_20_304 VPWR VGND sg13g2_fill_1
XFILLER_21_827 VPWR VGND sg13g2_decap_8
XFILLER_33_676 VPWR VGND sg13g2_decap_8
Xu_ppwm_u_ex__0965_ u_ppwm_u_ex__0965_/Y u_ppwm_u_ex__0965_/A u_ppwm_u_ex__0965_/B
+ VPWR VGND sg13g2_xnor2_1
XFILLER_20_326 VPWR VGND sg13g2_fill_1
XFILLER_32_175 VPWR VGND sg13g2_decap_8
Xu_ppwm_u_ex__0896_ u_ppwm_u_ex__0896_/Y u_ppwm_u_ex__0896_/A u_ppwm_u_ex__0896_/B
+ VPWR VGND sg13g2_nand2_1
XFILLER_29_927 VPWR VGND sg13g2_decap_8
XFILLER_44_908 VPWR VGND sg13g2_decap_8
XFILLER_15_109 VPWR VGND sg13g2_decap_8
XFILLER_24_621 VPWR VGND sg13g2_decap_8
XFILLER_36_470 VPWR VGND sg13g2_fill_1
XFILLER_23_142 VPWR VGND sg13g2_fill_2
XFILLER_23_164 VPWR VGND sg13g2_fill_1
XFILLER_24_698 VPWR VGND sg13g2_decap_8
XFILLER_11_348 VPWR VGND sg13g2_decap_4
XFILLER_12_849 VPWR VGND sg13g2_decap_8
XFILLER_20_860 VPWR VGND sg13g2_decap_8
XFILLER_3_525 VPWR VGND sg13g2_decap_8
XFILLER_2_4 VPWR VGND sg13g2_decap_8
Xfanout350 fanout350/A net350 VPWR VGND sg13g2_buf_8
XFILLER_47_702 VPWR VGND sg13g2_decap_8
XFILLER_4_1005 VPWR VGND sg13g2_decap_8
Xfanout361 fanout361/A net361 VPWR VGND sg13g2_buf_1
Xfanout372 net373 net372 VPWR VGND sg13g2_buf_8
Xfanout383 net385 net383 VPWR VGND sg13g2_buf_8
Xfanout394 net395 net394 VPWR VGND sg13g2_buf_8
XFILLER_47_779 VPWR VGND sg13g2_decap_8
XFILLER_35_919 VPWR VGND sg13g2_decap_8
XFILLER_27_470 VPWR VGND sg13g2_decap_8
XFILLER_34_418 VPWR VGND sg13g2_fill_1
XFILLER_15_654 VPWR VGND sg13g2_decap_8
XFILLER_43_974 VPWR VGND sg13g2_decap_8
XFILLER_14_175 VPWR VGND sg13g2_decap_8
Xu_ppwm_u_ex__0750_ net355 u_ppwm_u_ex__0750_/C u_ppwm_u_ex__0750_/A u_ppwm_u_ex__0776_/C
+ VPWR VGND sg13g2_nand3_1
Xu_ppwm_u_mem__0962_ VGND VPWR u_ppwm_u_mem__0651_/Y net387 u_ppwm_u_mem__1151_/D
+ u_ppwm_u_mem__0961_/Y sg13g2_a21oi_1
XFILLER_30_668 VPWR VGND sg13g2_decap_8
XFILLER_7_820 VPWR VGND sg13g2_decap_8
Xu_ppwm_u_pwm__204_ hold197/A hold229/A u_ppwm_u_pwm__214_/A VPWR VGND sg13g2_nor2b_1
XFILLER_11_871 VPWR VGND sg13g2_decap_8
Xu_ppwm_u_mem__0893_ net489 VPWR u_ppwm_u_mem__0893_/Y VGND net254 net401 sg13g2_o21ai_1
Xu_ppwm_u_ex__0681_ u_ppwm_u_ex__0681_/Y net448 net440 VPWR VGND sg13g2_nand2b_1
Xu_ppwm_u_pwm__135_ VPWR u_ppwm_u_pwm__135_/Y net580 VGND sg13g2_inv_1
XFILLER_7_897 VPWR VGND sg13g2_decap_8
XFILLER_42_1000 VPWR VGND sg13g2_decap_8
Xu_ppwm_u_global_counter__153_ VGND VPWR u_ppwm_u_global_counter__155_/B u_ppwm_u_global_counter__150_/B
+ hold255/A u_ppwm_u_global_counter__152_/Y sg13g2_a21oi_1
XFILLER_38_735 VPWR VGND sg13g2_decap_8
Xu_ppwm_u_ex__1095_ VGND VPWR u_ppwm_u_ex__1091_/Y u_ppwm_u_ex__1093_/X u_ppwm_u_ex__1100_/A
+ u_ppwm_u_ex__1094_/Y sg13g2_a21oi_1
XFILLER_46_790 VPWR VGND sg13g2_decap_8
XFILLER_34_941 VPWR VGND sg13g2_decap_8
XFILLER_33_451 VPWR VGND sg13g2_decap_4
XFILLER_21_624 VPWR VGND sg13g2_decap_8
XFILLER_20_145 VPWR VGND sg13g2_decap_8
Xu_ppwm_u_ex__0948_ u_ppwm_u_ex__0948_/Y u_ppwm_u_ex__0851_/X u_ppwm_u_ex__0846_/A
+ u_ppwm_u_ex__0966_/A u_ppwm_u_ex__0823_/X VPWR VGND sg13g2_a22oi_1
Xu_ppwm_u_ex__0879_ u_ppwm_u_ex__0880_/B net356 hold222/A net358 hold288/A VPWR VGND
+ sg13g2_a22oi_1
XFILLER_0_539 VPWR VGND sg13g2_decap_8
XFILLER_28_201 VPWR VGND sg13g2_fill_1
XFILLER_29_724 VPWR VGND sg13g2_decap_8
XFILLER_44_705 VPWR VGND sg13g2_decap_8
XFILLER_28_289 VPWR VGND sg13g2_fill_2
XFILLER_25_963 VPWR VGND sg13g2_decap_8
XFILLER_40_933 VPWR VGND sg13g2_decap_8
XFILLER_12_646 VPWR VGND sg13g2_decap_8
XFILLER_24_495 VPWR VGND sg13g2_decap_8
XFILLER_4_823 VPWR VGND sg13g2_decap_8
XFILLER_3_399 VPWR VGND sg13g2_decap_8
XFILLER_26_1028 VPWR VGND sg13g2_fill_1
XFILLER_19_234 VPWR VGND sg13g2_fill_2
Xu_ppwm_u_mem__1154__151 VPWR VGND net151 sg13g2_tiehi
Xu_ppwm_u_mem__1161_ net124 VGND VPWR net316 hold98/A clknet_5_8__leaf_clk sg13g2_dfrbpq_1
XFILLER_47_576 VPWR VGND sg13g2_decap_8
XFILLER_19_267 VPWR VGND sg13g2_decap_4
XFILLER_35_716 VPWR VGND sg13g2_decap_8
Xu_ppwm_u_mem__1092_ net166 VGND VPWR u_ppwm_u_mem__1092_/D hold121/A clknet_5_11__leaf_clk
+ sg13g2_dfrbpq_1
XFILLER_43_771 VPWR VGND sg13g2_decap_8
XFILLER_16_996 VPWR VGND sg13g2_decap_8
XFILLER_31_922 VPWR VGND sg13g2_decap_8
Xu_ppwm_u_ex__0802_ VGND VPWR net361 u_ppwm_u_ex__0799_/X u_ppwm_u_ex__0803_/B u_ppwm_u_ex__0801_/Y
+ sg13g2_a21oi_1
XFILLER_31_999 VPWR VGND sg13g2_decap_8
Xu_ppwm_u_ex__0733_ hold225/A hold264/A u_ppwm_u_ex__0733_/Y VPWR VGND sg13g2_nor2b_1
Xu_ppwm_u_mem__0945_ net488 VPWR u_ppwm_u_mem__0945_/Y VGND net548 net390 sg13g2_o21ai_1
Xu_ppwm_u_ex__0664_ u_ppwm_u_ex__0657_/Y VPWR u_ppwm_u_ex__0664_/Y VGND u_ppwm_u_ex__0658_/Y
+ u_ppwm_u_ex__0663_/Y sg13g2_o21ai_1
XFILLER_7_694 VPWR VGND sg13g2_decap_8
Xu_ppwm_u_mem__0876_ VGND VPWR u_ppwm_u_mem__0694_/Y net398 u_ppwm_u_mem__1108_/D
+ u_ppwm_u_mem__0875_/Y sg13g2_a21oi_1
Xu_ppwm_u_mem__1202__141 VPWR VGND net141 sg13g2_tiehi
Xu_ppwm_u_ex__0595_ VPWR u_ppwm_u_ex__0595_/Y hold281/A VGND sg13g2_inv_1
Xu_ppwm_u_global_counter__136_ VGND VPWR u_ppwm_u_global_counter__141_/C u_ppwm_u_global_counter__141_/D
+ u_ppwm_u_global_counter__136_/Y net429 sg13g2_a21oi_1
XFILLER_38_532 VPWR VGND sg13g2_decap_8
XFILLER_25_215 VPWR VGND sg13g2_decap_4
Xu_ppwm_u_ex__1078_ u_ppwm_u_ex__1087_/B VPWR u_ppwm_u_ex__1079_/C VGND u_ppwm_u_ex__1077_/A
+ u_ppwm_u_ex__1077_/B sg13g2_o21ai_1
XFILLER_40_218 VPWR VGND sg13g2_decap_4
XFILLER_22_966 VPWR VGND sg13g2_decap_8
XFILLER_21_498 VPWR VGND sg13g2_decap_8
XFILLER_49_1006 VPWR VGND sg13g2_decap_8
XFILLER_1_804 VPWR VGND sg13g2_decap_8
XFILLER_0_336 VPWR VGND sg13g2_decap_8
XFILLER_29_521 VPWR VGND sg13g2_decap_8
XFILLER_44_502 VPWR VGND sg13g2_decap_8
XFILLER_17_727 VPWR VGND sg13g2_decap_8
XFILLER_29_598 VPWR VGND sg13g2_decap_8
XFILLER_44_579 VPWR VGND sg13g2_decap_8
XFILLER_25_760 VPWR VGND sg13g2_decap_8
XFILLER_40_730 VPWR VGND sg13g2_decap_8
XFILLER_8_403 VPWR VGND sg13g2_decap_4
XFILLER_13_966 VPWR VGND sg13g2_decap_8
XFILLER_9_948 VPWR VGND sg13g2_decap_8
XFILLER_33_84 VPWR VGND sg13g2_fill_2
XFILLER_8_458 VPWR VGND sg13g2_decap_8
Xu_ppwm_u_mem__0730_ hold132/A hold69/A net463 u_ppwm_u_mem__0730_/X VPWR VGND sg13g2_mux2_1
Xu_ppwm_u_mem__0661_ VPWR u_ppwm_u_mem__0661_/Y net233 VGND sg13g2_inv_1
XFILLER_4_620 VPWR VGND sg13g2_decap_8
XFILLER_4_697 VPWR VGND sg13g2_decap_8
Xhold3 hold3/A VPWR VGND net220 sg13g2_dlygate4sd3_1
XFILLER_48_863 VPWR VGND sg13g2_decap_8
Xu_ppwm_u_ex__1001_ VGND VPWR u_ppwm_u_ex__0998_/Y u_ppwm_u_ex__0999_/Y hold265/A
+ u_ppwm_u_ex__1000_/Y sg13g2_a21oi_1
XFILLER_47_351 VPWR VGND sg13g2_fill_2
XFILLER_35_513 VPWR VGND sg13g2_decap_8
Xu_ppwm_u_mem__1144_ net181 VGND VPWR u_ppwm_u_mem__1144_/D hold165/A clknet_5_13__leaf_clk
+ sg13g2_dfrbpq_1
Xu_ppwm_u_mem__1075_ net610 u_ppwm_u_mem__1075_/B u_ppwm_u_mem__1081_/B VPWR VGND
+ sg13g2_nor2_1
XFILLER_16_793 VPWR VGND sg13g2_decap_8
XFILLER_22_229 VPWR VGND sg13g2_decap_8
XFILLER_15_292 VPWR VGND sg13g2_decap_8
XFILLER_31_796 VPWR VGND sg13g2_decap_8
XFILLER_30_295 VPWR VGND sg13g2_decap_4
Xclkbuf_4_4_0_clk clknet_0_clk clknet_4_4_0_clk VPWR VGND sg13g2_buf_8
Xu_ppwm_u_mem__0928_ VGND VPWR u_ppwm_u_mem__0668_/Y net414 u_ppwm_u_mem__1134_/D
+ u_ppwm_u_mem__0927_/Y sg13g2_a21oi_1
Xu_ppwm_u_ex__0716_ VPWR VGND u_ppwm_u_ex__0714_/Y u_ppwm_u_ex__0715_/Y u_ppwm_u_ex__0713_/Y
+ hold297/A u_ppwm_u_ex__0716_/Y u_ppwm_u_ex__0596_/Y sg13g2_a221oi_1
XFILLER_7_491 VPWR VGND sg13g2_decap_8
Xu_ppwm_u_ex__0647_ u_ppwm_u_ex__0648_/C net451 net367 VPWR VGND sg13g2_xnor2_1
Xu_ppwm_u_mem__0859_ net485 VPWR u_ppwm_u_mem__0859_/Y VGND hold191/A net392 sg13g2_o21ai_1
Xu_ppwm_u_ex__0578_ hold276/A u_ppwm_u_ex__0721_/A VPWR VGND sg13g2_inv_4
XFILLER_39_885 VPWR VGND sg13g2_decap_8
Xu_ppwm_u_global_counter__119_ u_ppwm_u_global_counter__120_/A u_ppwm_u_global_counter__119_/B
+ u_ppwm_u_global_counter__121_/B VPWR VGND sg13g2_and2_1
XFILLER_26_557 VPWR VGND sg13g2_decap_8
XFILLER_41_538 VPWR VGND sg13g2_decap_8
XFILLER_13_218 VPWR VGND sg13g2_fill_2
XFILLER_22_763 VPWR VGND sg13g2_decap_8
XFILLER_10_936 VPWR VGND sg13g2_decap_8
XFILLER_6_918 VPWR VGND sg13g2_decap_8
XFILLER_21_295 VPWR VGND sg13g2_decap_8
XFILLER_1_601 VPWR VGND sg13g2_decap_8
XFILLER_0_122 VPWR VGND sg13g2_decap_8
XFILLER_1_678 VPWR VGND sg13g2_decap_8
XFILLER_49_649 VPWR VGND sg13g2_decap_8
XFILLER_0_199 VPWR VGND sg13g2_decap_8
XFILLER_29_351 VPWR VGND sg13g2_decap_4
XFILLER_45_844 VPWR VGND sg13g2_decap_8
XFILLER_17_524 VPWR VGND sg13g2_decap_8
XFILLER_9_745 VPWR VGND sg13g2_decap_8
XFILLER_12_251 VPWR VGND sg13g2_decap_8
XFILLER_13_763 VPWR VGND sg13g2_decap_8
XFILLER_8_255 VPWR VGND sg13g2_decap_4
Xu_ppwm_u_mem__0713_ VPWR u_ppwm_u_mem__0713_/Y net274 VGND sg13g2_inv_1
XFILLER_5_951 VPWR VGND sg13g2_decap_8
XFILLER_5_22 VPWR VGND sg13g2_fill_2
XFILLER_4_494 VPWR VGND sg13g2_decap_8
Xu_ppwm_u_mem__0644_ VPWR u_ppwm_u_mem__0644_/Y net577 VGND sg13g2_inv_1
XFILLER_5_99 VPWR VGND sg13g2_fill_2
XFILLER_48_660 VPWR VGND sg13g2_decap_8
XFILLER_36_844 VPWR VGND sg13g2_decap_8
Xu_ppwm_u_mem__1127_ net97 VGND VPWR u_ppwm_u_mem__1127_/D hold161/A clknet_5_30__leaf_clk
+ sg13g2_dfrbpq_1
XFILLER_35_354 VPWR VGND sg13g2_fill_2
XFILLER_16_590 VPWR VGND sg13g2_decap_8
Xu_ppwm_u_mem__1058_ VGND VPWR u_ppwm_u_mem__0603_/Y net387 hold160/A u_ppwm_u_mem__1057_/Y
+ sg13g2_a21oi_1
XFILLER_31_593 VPWR VGND sg13g2_decap_8
Xhold200 hold200/A VPWR VGND net583 sg13g2_dlygate4sd3_1
Xhold211 hold211/A VPWR VGND net594 sg13g2_dlygate4sd3_1
Xhold222 hold222/A VPWR VGND net605 sg13g2_dlygate4sd3_1
Xhold244 hold244/A VPWR VGND net627 sg13g2_dlygate4sd3_1
Xhold233 hold233/A VPWR VGND net616 sg13g2_dlygate4sd3_1
XFILLER_49_28 VPWR VGND sg13g2_decap_8
Xhold277 hold277/A VPWR VGND net660 sg13g2_dlygate4sd3_1
Xhold266 hold266/A VPWR VGND net649 sg13g2_dlygate4sd3_1
Xhold255 hold255/A VPWR VGND net638 sg13g2_dlygate4sd3_1
XFILLER_49_39 VPWR VGND sg13g2_fill_2
Xhold288 hold288/A VPWR VGND net671 sg13g2_dlygate4sd3_1
Xhold299 hold299/A VPWR VGND net682 sg13g2_dlygate4sd3_1
XFILLER_46_608 VPWR VGND sg13g2_decap_8
XFILLER_39_682 VPWR VGND sg13g2_decap_8
XFILLER_27_855 VPWR VGND sg13g2_decap_8
XFILLER_26_332 VPWR VGND sg13g2_fill_1
XFILLER_42_825 VPWR VGND sg13g2_decap_8
XFILLER_41_324 VPWR VGND sg13g2_fill_2
XFILLER_14_527 VPWR VGND sg13g2_decap_8
XFILLER_22_560 VPWR VGND sg13g2_decap_8
XFILLER_10_733 VPWR VGND sg13g2_decap_8
XFILLER_6_715 VPWR VGND sg13g2_decap_8
Xu_ppwm_u_ex__1121__33 VPWR VGND net33 sg13g2_tiehi
XFILLER_5_258 VPWR VGND sg13g2_fill_1
XFILLER_2_921 VPWR VGND sg13g2_decap_8
XFILLER_2_998 VPWR VGND sg13g2_decap_8
XFILLER_1_475 VPWR VGND sg13g2_decap_8
XFILLER_49_446 VPWR VGND sg13g2_decap_8
XFILLER_18_844 VPWR VGND sg13g2_decap_8
XFILLER_45_641 VPWR VGND sg13g2_decap_8
XFILLER_44_162 VPWR VGND sg13g2_fill_1
Xu_ppwm_u_ex__0981_ u_ppwm_u_ex__0981_/Y u_ppwm_u_ex__0966_/A u_ppwm_u_ex__0877_/X
+ u_ppwm_u_ex__0933_/B u_ppwm_u_ex__0822_/X VPWR VGND sg13g2_a22oi_1
XFILLER_33_858 VPWR VGND sg13g2_decap_8
XFILLER_13_560 VPWR VGND sg13g2_decap_8
XFILLER_9_542 VPWR VGND sg13g2_decap_8
XFILLER_4_291 VPWR VGND sg13g2_fill_1
Xu_ppwm_u_mem__0627_ VPWR u_ppwm_u_mem__0627_/Y net301 VGND sg13g2_inv_1
XFILLER_27_118 VPWR VGND sg13g2_decap_4
XFILLER_24_803 VPWR VGND sg13g2_decap_8
XFILLER_36_641 VPWR VGND sg13g2_decap_8
XFILLER_13_1008 VPWR VGND sg13g2_decap_8
XFILLER_3_707 VPWR VGND sg13g2_decap_8
XFILLER_4_8 VPWR VGND sg13g2_decap_8
XFILLER_27_652 VPWR VGND sg13g2_decap_8
XFILLER_42_622 VPWR VGND sg13g2_decap_8
XFILLER_14_302 VPWR VGND sg13g2_fill_1
XFILLER_15_836 VPWR VGND sg13g2_decap_8
XFILLER_42_699 VPWR VGND sg13g2_decap_8
Xu_ppwm_u_pwm__220_ u_ppwm_u_pwm__222_/D hold18/A hold245/A VPWR VGND sg13g2_nand2b_1
XFILLER_10_530 VPWR VGND sg13g2_decap_8
XFILLER_22_390 VPWR VGND sg13g2_fill_1
XFILLER_6_512 VPWR VGND sg13g2_decap_8
Xu_ppwm_u_pwm__151_ u_ppwm_u_pwm__152_/B net476 u_ppwm_u_pwm__151_/B VPWR VGND sg13g2_nand2_1
XFILLER_6_589 VPWR VGND sg13g2_decap_8
XFILLER_29_1004 VPWR VGND sg13g2_decap_8
XFILLER_49_232 VPWR VGND sg13g2_fill_2
XFILLER_2_795 VPWR VGND sg13g2_decap_8
XFILLER_38_917 VPWR VGND sg13g2_decap_8
XFILLER_46_972 VPWR VGND sg13g2_decap_8
XFILLER_18_641 VPWR VGND sg13g2_decap_8
XFILLER_33_655 VPWR VGND sg13g2_decap_8
XFILLER_21_806 VPWR VGND sg13g2_decap_8
XFILLER_36_1019 VPWR VGND sg13g2_decap_8
XFILLER_14_891 VPWR VGND sg13g2_decap_8
Xu_ppwm_u_ex__0964_ net362 net441 u_ppwm_u_ex__0965_/B VPWR VGND sg13g2_xor2_1
Xu_ppwm_u_ex__0895_ u_ppwm_u_ex__0894_/Y VPWR u_ppwm_u_ex__0901_/A VGND u_ppwm_u_ex__0809_/Y
+ u_ppwm_u_ex__0872_/B sg13g2_o21ai_1
XFILLER_29_906 VPWR VGND sg13g2_decap_8
XFILLER_24_600 VPWR VGND sg13g2_decap_8
XFILLER_37_994 VPWR VGND sg13g2_decap_8
XFILLER_12_828 VPWR VGND sg13g2_decap_8
XFILLER_24_677 VPWR VGND sg13g2_decap_8
XFILLER_3_504 VPWR VGND sg13g2_decap_8
XFILLER_11_54 VPWR VGND sg13g2_fill_1
Xfanout351 net354 net351 VPWR VGND sg13g2_buf_8
Xfanout362 net363 net362 VPWR VGND sg13g2_buf_8
Xfanout373 net374 net373 VPWR VGND sg13g2_buf_8
Xfanout384 net385 net384 VPWR VGND sg13g2_buf_1
Xfanout395 net396 net395 VPWR VGND sg13g2_buf_8
XFILLER_4_1028 VPWR VGND sg13g2_fill_1
XFILLER_19_438 VPWR VGND sg13g2_fill_1
XFILLER_47_758 VPWR VGND sg13g2_decap_8
XFILLER_19_449 VPWR VGND sg13g2_fill_2
XFILLER_28_994 VPWR VGND sg13g2_decap_8
XFILLER_43_953 VPWR VGND sg13g2_decap_8
XFILLER_14_110 VPWR VGND sg13g2_fill_1
XFILLER_15_633 VPWR VGND sg13g2_decap_8
XFILLER_42_496 VPWR VGND sg13g2_decap_8
XFILLER_30_647 VPWR VGND sg13g2_decap_8
XFILLER_11_850 VPWR VGND sg13g2_decap_8
Xu_ppwm_u_mem__0961_ net487 VPWR u_ppwm_u_mem__0961_/Y VGND net282 net387 sg13g2_o21ai_1
Xu_ppwm_u_mem__0892_ VGND VPWR u_ppwm_u_mem__0686_/Y net403 hold77/A u_ppwm_u_mem__0891_/Y
+ sg13g2_a21oi_1
Xu_ppwm_u_pwm__203_ u_ppwm_u_pwm__203_/Y u_ppwm_u_pwm__230_/A u_ppwm_u_pwm__203_/B
+ VPWR VGND sg13g2_nand2_1
XFILLER_10_393 VPWR VGND sg13g2_fill_1
Xu_ppwm_u_ex__0680_ u_ppwm_u_ex__0679_/Y VPWR u_ppwm_u_ex__0680_/Y VGND net437 u_ppwm_u_ex__0658_/A
+ sg13g2_o21ai_1
XFILLER_7_876 VPWR VGND sg13g2_decap_8
Xu_ppwm_u_pwm__134_ VPWR u_ppwm_u_pwm__134_/Y net578 VGND sg13g2_inv_1
Xu_ppwm_u_global_counter__170__66 VPWR VGND net66 sg13g2_tiehi
XFILLER_2_592 VPWR VGND sg13g2_decap_8
XFILLER_28_4 VPWR VGND sg13g2_decap_8
XFILLER_38_714 VPWR VGND sg13g2_decap_8
Xu_ppwm_u_global_counter__152_ net480 VPWR u_ppwm_u_global_counter__152_/Y VGND u_ppwm_u_global_counter__155_/B
+ u_ppwm_u_global_counter__150_/B sg13g2_o21ai_1
XFILLER_37_224 VPWR VGND sg13g2_decap_8
Xu_ppwm_u_ex__1094_ net350 VPWR u_ppwm_u_ex__1094_/Y VGND u_ppwm_u_ex__1091_/Y u_ppwm_u_ex__1093_/X
+ sg13g2_o21ai_1
XFILLER_37_235 VPWR VGND sg13g2_fill_2
XFILLER_25_408 VPWR VGND sg13g2_fill_1
XFILLER_34_920 VPWR VGND sg13g2_decap_8
XFILLER_21_603 VPWR VGND sg13g2_decap_8
XFILLER_34_997 VPWR VGND sg13g2_decap_8
Xu_ppwm_u_ex__0947_ VGND VPWR u_ppwm_u_ex__0946_/A u_ppwm_u_ex__0958_/C u_ppwm_u_ex__0947_/Y
+ net349 sg13g2_a21oi_1
Xu_ppwm_u_ex__0878_ VPWR VGND u_ppwm_u_ex__0803_/A u_ppwm_u_ex__0874_/Y u_ppwm_u_ex__0877_/X
+ u_ppwm_u_ex__0804_/Y u_ppwm_u_ex__1033_/A u_ppwm_u_ex__0823_/X sg13g2_a221oi_1
Xclkbuf_5_15__f_clk clknet_4_7_0_clk clknet_5_15__leaf_clk VPWR VGND sg13g2_buf_8
XFILLER_0_518 VPWR VGND sg13g2_decap_8
XFILLER_29_703 VPWR VGND sg13g2_decap_8
XFILLER_17_909 VPWR VGND sg13g2_decap_8
XFILLER_25_942 VPWR VGND sg13g2_decap_8
XFILLER_37_791 VPWR VGND sg13g2_decap_8
XFILLER_40_912 VPWR VGND sg13g2_decap_8
XFILLER_12_625 VPWR VGND sg13g2_decap_8
XFILLER_24_474 VPWR VGND sg13g2_decap_8
XFILLER_40_989 VPWR VGND sg13g2_decap_8
XFILLER_11_135 VPWR VGND sg13g2_decap_4
XFILLER_4_802 VPWR VGND sg13g2_decap_8
XFILLER_4_879 VPWR VGND sg13g2_decap_8
XFILLER_47_555 VPWR VGND sg13g2_decap_8
Xu_ppwm_u_mem__1160_ net127 VGND VPWR u_ppwm_u_mem__1160_/D hold109/A clknet_5_9__leaf_clk
+ sg13g2_dfrbpq_1
Xu_ppwm_u_mem__1091_ net168 VGND VPWR net308 hold90/A clknet_5_10__leaf_clk sg13g2_dfrbpq_1
XFILLER_28_791 VPWR VGND sg13g2_decap_8
XFILLER_43_750 VPWR VGND sg13g2_decap_8
XFILLER_16_975 VPWR VGND sg13g2_decap_8
XFILLER_31_901 VPWR VGND sg13g2_decap_8
XFILLER_42_282 VPWR VGND sg13g2_fill_2
XFILLER_30_422 VPWR VGND sg13g2_decap_4
XFILLER_8_33 VPWR VGND sg13g2_fill_1
Xu_ppwm_u_ex__0801_ net361 u_ppwm_u_ex__0801_/B u_ppwm_u_ex__0801_/Y VPWR VGND sg13g2_nor2_1
XFILLER_31_978 VPWR VGND sg13g2_decap_8
Xu_ppwm_u_mem__0944_ VGND VPWR u_ppwm_u_mem__0660_/Y net412 hold13/A u_ppwm_u_mem__0943_/Y
+ sg13g2_a21oi_1
Xu_ppwm_u_ex__0732_ u_ppwm_u_ex__0732_/Y hold296/A hold299/A VPWR VGND sg13g2_nand2b_1
Xu_ppwm_u_mem__1122__107 VPWR VGND net107 sg13g2_tiehi
Xu_ppwm_u_ex__0663_ VPWR VGND u_ppwm_u_ex__0662_/Y u_ppwm_u_ex__0659_/Y u_ppwm_u_ex__0661_/Y
+ u_ppwm_u_ex__0658_/A u_ppwm_u_ex__0663_/Y hold288/A sg13g2_a221oi_1
XFILLER_7_673 VPWR VGND sg13g2_decap_8
XFILLER_6_161 VPWR VGND sg13g2_fill_2
Xu_ppwm_u_mem__0875_ net490 VPWR u_ppwm_u_mem__0875_/Y VGND net286 net398 sg13g2_o21ai_1
Xu_ppwm_u_ex__0594_ VPWR u_ppwm_u_ex__0722_/B hold259/A VGND sg13g2_inv_1
XFILLER_38_511 VPWR VGND sg13g2_decap_8
Xu_ppwm_u_global_counter__135_ u_ppwm_u_global_counter__141_/C u_ppwm_u_global_counter__141_/D
+ u_ppwm_u_global_counter__138_/B VPWR VGND sg13g2_nor2_1
XFILLER_19_0 VPWR VGND sg13g2_fill_2
XFILLER_26_739 VPWR VGND sg13g2_decap_8
XFILLER_38_588 VPWR VGND sg13g2_decap_8
Xu_ppwm_u_ex__1077_ u_ppwm_u_ex__1077_/A u_ppwm_u_ex__1077_/B u_ppwm_u_ex__1087_/B
+ u_ppwm_u_ex__1079_/B VPWR VGND sg13g2_or3_1
Xu_ppwm_u_pwm__237__203 VPWR VGND net203 sg13g2_tiehi
XFILLER_22_945 VPWR VGND sg13g2_decap_8
XFILLER_34_794 VPWR VGND sg13g2_decap_8
XFILLER_33_282 VPWR VGND sg13g2_fill_2
XFILLER_21_477 VPWR VGND sg13g2_decap_8
XFILLER_48_308 VPWR VGND sg13g2_decap_4
XFILLER_29_500 VPWR VGND sg13g2_decap_8
XFILLER_17_20 VPWR VGND sg13g2_fill_1
XFILLER_17_706 VPWR VGND sg13g2_decap_8
XFILLER_29_577 VPWR VGND sg13g2_decap_8
XFILLER_16_216 VPWR VGND sg13g2_fill_1
XFILLER_44_558 VPWR VGND sg13g2_decap_8
XFILLER_13_945 VPWR VGND sg13g2_decap_8
XFILLER_31_219 VPWR VGND sg13g2_decap_8
XFILLER_9_927 VPWR VGND sg13g2_decap_8
XFILLER_40_786 VPWR VGND sg13g2_decap_8
XFILLER_12_499 VPWR VGND sg13g2_decap_8
Xu_ppwm_u_mem__0660_ VPWR u_ppwm_u_mem__0660_/Y net229 VGND sg13g2_inv_1
XFILLER_3_120 VPWR VGND sg13g2_decap_8
XFILLER_4_676 VPWR VGND sg13g2_decap_8
Xhold4 hold4/A VPWR VGND net221 sg13g2_dlygate4sd3_1
XFILLER_0_882 VPWR VGND sg13g2_decap_8
XFILLER_48_842 VPWR VGND sg13g2_decap_8
Xu_ppwm_u_ex__1000_ net496 VPWR u_ppwm_u_ex__1000_/Y VGND net647 net342 sg13g2_o21ai_1
Xu_ppwm_u_mem__1212_ net477 VGND VPWR net220 u_ppwm_u_mem__1212_/Q clknet_5_3__leaf_clk
+ sg13g2_dfrbpq_1
Xu_ppwm_u_mem__1143_ net183 VGND VPWR u_ppwm_u_mem__1143_/D hold172/A clknet_5_24__leaf_clk
+ sg13g2_dfrbpq_2
Xu_ppwm_u_mem__1074_ VPWR VGND net381 u_ppwm_u_mem__1073_/Y net561 u_ppwm_u_mem__0718_/C
+ hold179/A u_ppwm_u_mem__1066_/Y sg13g2_a221oi_1
XFILLER_35_569 VPWR VGND sg13g2_decap_8
XFILLER_15_271 VPWR VGND sg13g2_decap_8
XFILLER_16_772 VPWR VGND sg13g2_decap_8
XFILLER_22_208 VPWR VGND sg13g2_decap_8
XFILLER_31_775 VPWR VGND sg13g2_decap_8
Xu_ppwm_u_mem__0927_ net501 VPWR u_ppwm_u_mem__0927_/Y VGND net324 net415 sg13g2_o21ai_1
Xu_ppwm_u_ex__0715_ u_ppwm_u_ex__0715_/A net422 u_ppwm_u_ex__0715_/Y VPWR VGND sg13g2_nor2_1
XFILLER_7_470 VPWR VGND sg13g2_decap_8
Xu_ppwm_u_mem__0858_ VGND VPWR u_ppwm_u_mem__0703_/Y net395 hold113/A u_ppwm_u_mem__0857_/Y
+ sg13g2_a21oi_1
Xu_ppwm_u_ex__0646_ VPWR VGND u_ppwm_u_ex__0645_/Y u_ppwm_u_ex__0782_/A u_ppwm_u_ex__0644_/Y
+ u_ppwm_u_ex__0586_/Y u_ppwm_u_ex__1118_/D u_ppwm_u_ex__0630_/X sg13g2_a221oi_1
Xu_ppwm_u_ex__0577_ u_ppwm_u_ex__0896_/A net441 VPWR VGND sg13g2_inv_2
Xu_ppwm_u_mem__0789_ VGND VPWR u_ppwm_u_mem__0787_/Y u_ppwm_u_mem__0788_/Y u_ppwm_u_mem__0789_/Y
+ net459 sg13g2_a21oi_1
XFILLER_39_864 VPWR VGND sg13g2_decap_8
Xu_ppwm_u_global_counter__118_ net652 u_ppwm_u_global_counter__118_/B hold270/A VPWR
+ VGND sg13g2_nor2_1
Xu_ppwm_u_ex__1129_ net44 VGND VPWR u_ppwm_u_ex__1129_/D hold276/A clknet_5_6__leaf_clk
+ sg13g2_dfrbpq_2
XFILLER_26_536 VPWR VGND sg13g2_decap_8
XFILLER_14_709 VPWR VGND sg13g2_decap_8
XFILLER_41_517 VPWR VGND sg13g2_decap_8
XFILLER_16_1017 VPWR VGND sg13g2_decap_8
XFILLER_22_742 VPWR VGND sg13g2_decap_8
XFILLER_34_591 VPWR VGND sg13g2_decap_8
XFILLER_10_915 VPWR VGND sg13g2_decap_8
XFILLER_16_1028 VPWR VGND sg13g2_fill_1
XFILLER_21_274 VPWR VGND sg13g2_fill_2
XFILLER_0_101 VPWR VGND sg13g2_decap_8
XFILLER_1_657 VPWR VGND sg13g2_decap_8
XFILLER_49_628 VPWR VGND sg13g2_decap_8
XFILLER_0_178 VPWR VGND sg13g2_decap_8
XFILLER_17_503 VPWR VGND sg13g2_decap_8
XFILLER_45_823 VPWR VGND sg13g2_decap_8
XFILLER_13_742 VPWR VGND sg13g2_decap_8
XFILLER_9_724 VPWR VGND sg13g2_decap_8
XFILLER_12_263 VPWR VGND sg13g2_decap_8
XFILLER_40_583 VPWR VGND sg13g2_decap_8
Xu_ppwm_u_mem__0712_ VPWR u_ppwm_u_mem__0712_/Y net276 VGND sg13g2_inv_1
XFILLER_5_930 VPWR VGND sg13g2_decap_8
XFILLER_5_56 VPWR VGND sg13g2_fill_2
XFILLER_4_473 VPWR VGND sg13g2_decap_8
Xu_ppwm_u_mem__0643_ VPWR u_ppwm_u_mem__0643_/Y net298 VGND sg13g2_inv_1
XFILLER_36_823 VPWR VGND sg13g2_decap_8
Xu_ppwm_u_mem__1126_ net99 VGND VPWR net328 hold110/A clknet_5_30__leaf_clk sg13g2_dfrbpq_1
XFILLER_23_539 VPWR VGND sg13g2_decap_8
Xu_ppwm_u_mem__1057_ net476 VPWR u_ppwm_u_mem__1057_/Y VGND u_ppwm_u_mem__1209_/Q
+ net381 sg13g2_o21ai_1
XFILLER_31_572 VPWR VGND sg13g2_decap_8
Xhold201 hold201/A VPWR VGND net584 sg13g2_dlygate4sd3_1
Xhold223 hold223/A VPWR VGND net606 sg13g2_dlygate4sd3_1
Xhold234 hold234/A VPWR VGND net617 sg13g2_dlygate4sd3_1
Xhold212 hold212/A VPWR VGND net595 sg13g2_dlygate4sd3_1
Xhold245 hold245/A VPWR VGND net628 sg13g2_dlygate4sd3_1
Xhold267 hold267/A VPWR VGND net650 sg13g2_dlygate4sd3_1
Xhold256 hold256/A VPWR VGND net639 sg13g2_dlygate4sd3_1
Xhold278 hold278/A VPWR VGND net661 sg13g2_dlygate4sd3_1
Xu_ppwm_u_ex__0629_ VGND VPWR u_ppwm_u_ex__0637_/A u_ppwm_u_ex__0627_/Y u_ppwm_u_ex__1116_/D
+ u_ppwm_u_ex__0628_/Y sg13g2_a21oi_1
Xhold289 hold289/A VPWR VGND net672 sg13g2_dlygate4sd3_1
XFILLER_39_661 VPWR VGND sg13g2_decap_8
XFILLER_27_834 VPWR VGND sg13g2_decap_8
XFILLER_42_804 VPWR VGND sg13g2_decap_8
XFILLER_14_506 VPWR VGND sg13g2_decap_8
XFILLER_41_336 VPWR VGND sg13g2_fill_1
XFILLER_14_32 VPWR VGND sg13g2_decap_8
XFILLER_10_712 VPWR VGND sg13g2_decap_8
XFILLER_10_789 VPWR VGND sg13g2_decap_8
XFILLER_2_900 VPWR VGND sg13g2_decap_8
XFILLER_2_977 VPWR VGND sg13g2_decap_8
XFILLER_1_454 VPWR VGND sg13g2_decap_8
XFILLER_49_425 VPWR VGND sg13g2_decap_8
Xclkbuf_4_3_0_clk clknet_0_clk clknet_4_3_0_clk VPWR VGND sg13g2_buf_8
XFILLER_37_609 VPWR VGND sg13g2_decap_8
XFILLER_45_620 VPWR VGND sg13g2_decap_8
XFILLER_18_823 VPWR VGND sg13g2_decap_8
XFILLER_45_697 VPWR VGND sg13g2_decap_8
XFILLER_17_377 VPWR VGND sg13g2_fill_1
XFILLER_17_388 VPWR VGND sg13g2_decap_4
XFILLER_33_837 VPWR VGND sg13g2_decap_8
Xu_ppwm_u_ex__0980_ u_ppwm_u_ex__0979_/Y VPWR u_ppwm_u_ex__0980_/Y VGND u_ppwm_u_ex__0977_/Y
+ u_ppwm_u_ex__0978_/X sg13g2_o21ai_1
XFILLER_41_881 VPWR VGND sg13g2_decap_8
XFILLER_9_521 VPWR VGND sg13g2_decap_8
XFILLER_9_598 VPWR VGND sg13g2_decap_8
Xu_ppwm_u_mem__1199__86 VPWR VGND net86 sg13g2_tiehi
Xu_ppwm_u_mem__0626_ VPWR u_ppwm_u_mem__0626_/Y net528 VGND sg13g2_inv_1
XFILLER_28_609 VPWR VGND sg13g2_decap_8
Xu_ppwm_u_mem__1093__164 VPWR VGND net164 sg13g2_tiehi
XFILLER_49_992 VPWR VGND sg13g2_decap_8
XFILLER_36_620 VPWR VGND sg13g2_decap_8
XFILLER_36_697 VPWR VGND sg13g2_decap_8
Xu_ppwm_u_mem__1109_ net132 VGND VPWR u_ppwm_u_mem__1109_/D hold69/A clknet_5_15__leaf_clk
+ sg13g2_dfrbpq_1
XFILLER_23_325 VPWR VGND sg13g2_decap_4
XFILLER_24_859 VPWR VGND sg13g2_decap_8
Xu_ppwm_u_global_counter__176__61 VPWR VGND net61 sg13g2_tiehi
Xu_ppwm_u_mem__1141__187 VPWR VGND net187 sg13g2_tiehi
Xfanout500 net501 net500 VPWR VGND sg13g2_buf_8
XFILLER_27_631 VPWR VGND sg13g2_decap_8
XFILLER_42_601 VPWR VGND sg13g2_decap_8
XFILLER_15_815 VPWR VGND sg13g2_decap_8
XFILLER_26_163 VPWR VGND sg13g2_fill_2
XFILLER_42_678 VPWR VGND sg13g2_decap_8
XFILLER_30_829 VPWR VGND sg13g2_decap_8
Xu_ppwm_u_pwm__150_ net596 net588 u_ppwm_u_pwm__154_/A u_ppwm_u_pwm__151_/B VPWR VGND
+ sg13g2_nand3_1
Xu_ppwm_u_global_counter__167__72 VPWR VGND net72 sg13g2_tiehi
XFILLER_10_586 VPWR VGND sg13g2_decap_8
XFILLER_6_568 VPWR VGND sg13g2_decap_8
XFILLER_2_774 VPWR VGND sg13g2_decap_8
XFILLER_49_255 VPWR VGND sg13g2_decap_8
XFILLER_49_244 VPWR VGND sg13g2_decap_8
XFILLER_18_620 VPWR VGND sg13g2_decap_8
XFILLER_46_951 VPWR VGND sg13g2_decap_8
XFILLER_45_494 VPWR VGND sg13g2_decap_8
XFILLER_18_697 VPWR VGND sg13g2_decap_8
XFILLER_33_634 VPWR VGND sg13g2_decap_8
XFILLER_14_870 VPWR VGND sg13g2_decap_8
Xu_ppwm_u_ex__0963_ net441 net363 u_ppwm_u_ex__0963_/Y VPWR VGND sg13g2_nor2_1
XFILLER_9_351 VPWR VGND sg13g2_fill_2
Xu_ppwm_u_ex__0894_ VGND VPWR u_ppwm_u_ex__0846_/A u_ppwm_u_ex__0799_/X u_ppwm_u_ex__0894_/Y
+ u_ppwm_u_ex__0893_/Y sg13g2_a21oi_1
Xu_ppwm_u_global_counter__173__75 VPWR VGND net75 sg13g2_tiehi
XFILLER_49_0 VPWR VGND sg13g2_decap_8
Xu_ppwm_u_mem__0609_ VPWR u_ppwm_u_mem__0609_/Y net241 VGND sg13g2_inv_1
XFILLER_37_973 VPWR VGND sg13g2_decap_8
XFILLER_36_494 VPWR VGND sg13g2_decap_8
XFILLER_12_807 VPWR VGND sg13g2_decap_8
XFILLER_23_133 VPWR VGND sg13g2_decap_4
XFILLER_23_144 VPWR VGND sg13g2_fill_1
XFILLER_23_155 VPWR VGND sg13g2_decap_4
XFILLER_24_656 VPWR VGND sg13g2_decap_8
XFILLER_11_317 VPWR VGND sg13g2_decap_4
XFILLER_23_177 VPWR VGND sg13g2_decap_8
XFILLER_20_895 VPWR VGND sg13g2_decap_8
Xfanout341 fanout343/A net341 VPWR VGND sg13g2_buf_8
Xfanout352 net353 net352 VPWR VGND sg13g2_buf_8
Xfanout363 net364 net363 VPWR VGND sg13g2_buf_1
Xfanout374 fanout374/A net374 VPWR VGND sg13g2_buf_8
XFILLER_47_737 VPWR VGND sg13g2_decap_8
Xfanout396 net397 net396 VPWR VGND sg13g2_buf_8
XFILLER_19_406 VPWR VGND sg13g2_fill_2
Xfanout385 net386 net385 VPWR VGND sg13g2_buf_8
XFILLER_46_269 VPWR VGND sg13g2_fill_1
XFILLER_15_612 VPWR VGND sg13g2_decap_8
XFILLER_28_973 VPWR VGND sg13g2_decap_8
XFILLER_43_932 VPWR VGND sg13g2_decap_8
XFILLER_42_475 VPWR VGND sg13g2_decap_8
XFILLER_14_188 VPWR VGND sg13g2_fill_1
XFILLER_15_689 VPWR VGND sg13g2_decap_8
XFILLER_30_626 VPWR VGND sg13g2_decap_8
Xu_ppwm_u_pwm__202_ u_ppwm_u_pwm__203_/B hold192/A u_ppwm_u_pwm__202_/B VPWR VGND
+ sg13g2_nand2_1
Xu_ppwm_u_mem__0960_ VGND VPWR u_ppwm_u_mem__0652_/Y net389 hold21/A u_ppwm_u_mem__0959_/Y
+ sg13g2_a21oi_1
Xu_ppwm_u_mem__0891_ net489 VPWR u_ppwm_u_mem__0891_/Y VGND hold152/A net401 sg13g2_o21ai_1
XFILLER_10_372 VPWR VGND sg13g2_fill_2
Xu_ppwm_u_pwm__133_ VPWR u_ppwm_u_pwm__133_/Y net539 VGND sg13g2_inv_1
XFILLER_7_855 VPWR VGND sg13g2_decap_8
XFILLER_6_343 VPWR VGND sg13g2_decap_8
XFILLER_2_571 VPWR VGND sg13g2_decap_8
Xu_ppwm_u_global_counter__151_ VGND VPWR u_ppwm_u_global_counter__155_/C u_ppwm_u_global_counter__147_/B
+ hold257/A u_ppwm_u_global_counter__150_/Y sg13g2_a21oi_1
Xu_ppwm_u_ex__1093_ net363 net431 u_ppwm_u_ex__1093_/X VPWR VGND sg13g2_xor2_1
XFILLER_19_984 VPWR VGND sg13g2_decap_8
XFILLER_18_494 VPWR VGND sg13g2_decap_8
XFILLER_34_976 VPWR VGND sg13g2_decap_8
XFILLER_33_475 VPWR VGND sg13g2_fill_2
Xu_ppwm_u_ex__0946_ VGND VPWR u_ppwm_u_ex__0946_/X u_ppwm_u_ex__0958_/C u_ppwm_u_ex__0946_/A
+ sg13g2_or2_1
XFILLER_20_125 VPWR VGND sg13g2_decap_8
XFILLER_21_659 VPWR VGND sg13g2_decap_8
Xu_ppwm_u_ex__0877_ u_ppwm_u_ex__0851_/X u_ppwm_u_ex__0898_/B net368 u_ppwm_u_ex__0877_/X
+ VPWR VGND sg13g2_mux2_1
XFILLER_29_759 VPWR VGND sg13g2_decap_8
XFILLER_37_770 VPWR VGND sg13g2_decap_8
XFILLER_25_921 VPWR VGND sg13g2_decap_8
XFILLER_12_604 VPWR VGND sg13g2_decap_8
XFILLER_19_1026 VPWR VGND sg13g2_fill_2
XFILLER_24_453 VPWR VGND sg13g2_decap_8
XFILLER_25_998 VPWR VGND sg13g2_decap_8
XFILLER_40_968 VPWR VGND sg13g2_decap_8
XFILLER_8_619 VPWR VGND sg13g2_decap_8
XFILLER_11_125 VPWR VGND sg13g2_decap_4
XFILLER_11_169 VPWR VGND sg13g2_decap_8
XFILLER_20_692 VPWR VGND sg13g2_decap_8
XFILLER_4_858 VPWR VGND sg13g2_decap_8
XFILLER_26_1019 VPWR VGND sg13g2_decap_8
XFILLER_47_534 VPWR VGND sg13g2_decap_8
Xu_ppwm_u_mem__1090_ net170 VGND VPWR net277 hold59/A clknet_5_10__leaf_clk sg13g2_dfrbpq_1
XFILLER_28_770 VPWR VGND sg13g2_decap_8
Xclkbuf_5_21__f_clk clknet_4_10_0_clk clknet_5_21__leaf_clk VPWR VGND sg13g2_buf_8
XFILLER_16_954 VPWR VGND sg13g2_decap_8
XFILLER_15_486 VPWR VGND sg13g2_decap_8
Xu_ppwm_u_ex__0800_ net444 net435 net375 u_ppwm_u_ex__0801_/B VPWR VGND sg13g2_mux2_1
XFILLER_31_957 VPWR VGND sg13g2_decap_8
Xu_ppwm_u_mem__0943_ net500 VPWR u_ppwm_u_mem__0943_/Y VGND hold172/A net411 sg13g2_o21ai_1
Xu_ppwm_u_ex__0731_ u_ppwm_u_ex__0730_/Y VPWR u_ppwm_u_ex__0731_/Y VGND net437 u_ppwm_u_ex__0598_/Y
+ sg13g2_o21ai_1
XFILLER_7_652 VPWR VGND sg13g2_decap_8
Xu_ppwm_u_mem__1161__124 VPWR VGND net124 sg13g2_tiehi
Xu_ppwm_u_mem__0874_ VGND VPWR u_ppwm_u_mem__0695_/Y net398 hold62/A u_ppwm_u_mem__0873_/Y
+ sg13g2_a21oi_1
Xu_ppwm_u_ex__0662_ u_ppwm_u_ex__0662_/Y u_ppwm_u_ex__0606_/Y net448 u_ppwm_u_ex__0751_/B
+ net446 VPWR VGND sg13g2_a22oi_1
Xu_ppwm_u_ex__0593_ VPWR u_ppwm_u_ex__0623_/A hold231/A VGND sg13g2_inv_1
Xu_ppwm_u_global_counter__134_ VGND VPWR u_ppwm_u_global_counter__096_/Y u_ppwm_u_global_counter__130_/B
+ hold226/A u_ppwm_u_global_counter__133_/Y sg13g2_a21oi_1
XFILLER_26_718 VPWR VGND sg13g2_decap_8
XFILLER_38_567 VPWR VGND sg13g2_decap_8
XFILLER_19_781 VPWR VGND sg13g2_decap_8
Xu_ppwm_u_ex__1076_ net364 hold275/A u_ppwm_u_ex__1087_/B VPWR VGND sg13g2_xor2_1
XFILLER_22_924 VPWR VGND sg13g2_decap_8
XFILLER_34_773 VPWR VGND sg13g2_decap_8
Xu_ppwm_u_ex__0929_ u_ppwm_u_ex__0958_/B u_ppwm_u_ex__0929_/B u_ppwm_u_ex__0886_/Y
+ VPWR VGND sg13g2_nand2b_1
XFILLER_30_990 VPWR VGND sg13g2_decap_8
XFILLER_0_327 VPWR VGND sg13g2_decap_4
XFILLER_1_839 VPWR VGND sg13g2_decap_8
XFILLER_29_556 VPWR VGND sg13g2_decap_8
XFILLER_44_537 VPWR VGND sg13g2_decap_8
Xu_ppwm_u_mem__1171__84 VPWR VGND net84 sg13g2_tiehi
XFILLER_12_401 VPWR VGND sg13g2_decap_8
XFILLER_12_412 VPWR VGND sg13g2_fill_2
XFILLER_13_924 VPWR VGND sg13g2_decap_8
XFILLER_25_795 VPWR VGND sg13g2_decap_8
XFILLER_9_906 VPWR VGND sg13g2_decap_8
XFILLER_40_765 VPWR VGND sg13g2_decap_8
XFILLER_12_478 VPWR VGND sg13g2_decap_8
XFILLER_32_1012 VPWR VGND sg13g2_decap_8
XFILLER_33_86 VPWR VGND sg13g2_fill_1
XFILLER_4_655 VPWR VGND sg13g2_decap_8
XFILLER_48_821 VPWR VGND sg13g2_decap_8
XFILLER_0_861 VPWR VGND sg13g2_decap_8
Xhold5 hold5/A VPWR VGND net222 sg13g2_dlygate4sd3_1
XFILLER_12_8 VPWR VGND sg13g2_fill_2
Xu_ppwm_u_mem__1211_ net484 VGND VPWR net218 hold3/A clknet_5_9__leaf_clk sg13g2_dfrbpq_1
Xu_ppwm_u_mem__1142_ net185 VGND VPWR net230 hold12/A clknet_5_27__leaf_clk sg13g2_dfrbpq_1
XFILLER_48_898 VPWR VGND sg13g2_decap_8
XFILLER_47_397 VPWR VGND sg13g2_decap_8
XFILLER_35_548 VPWR VGND sg13g2_decap_8
XFILLER_16_751 VPWR VGND sg13g2_decap_8
Xu_ppwm_u_mem__1073_ net477 VPWR u_ppwm_u_mem__1073_/Y VGND net381 u_ppwm_u_mem__1080_/C
+ sg13g2_o21ai_1
XFILLER_31_754 VPWR VGND sg13g2_decap_8
Xu_ppwm_u_mem__0926_ VGND VPWR u_ppwm_u_mem__0669_/Y net414 hold50/A u_ppwm_u_mem__0925_/Y
+ sg13g2_a21oi_1
XFILLER_8_983 VPWR VGND sg13g2_decap_8
Xu_ppwm_u_ex__0714_ u_ppwm_u_ex__0714_/Y hold262/A u_ppwm_u_ex__0689_/B net422 u_ppwm_u_ex__0715_/A
+ VPWR VGND sg13g2_a22oi_1
Xu_ppwm_u_mem__0857_ net486 VPWR u_ppwm_u_mem__0857_/Y VGND hold186/A net392 sg13g2_o21ai_1
Xu_ppwm_u_ex__0645_ VGND VPWR u_ppwm_u_ex__0651_/B u_ppwm_u_ex__0652_/B u_ppwm_u_ex__0645_/Y
+ u_ppwm_u_ex__0995_/A sg13g2_a21oi_1
Xu_ppwm_u_ex__0576_ u_ppwm_u_ex__0719_/A hold271/A VPWR VGND sg13g2_inv_2
Xu_ppwm_u_mem__0788_ u_ppwm_u_mem__0788_/Y hold145/A net469 VPWR VGND sg13g2_nand2b_1
XFILLER_31_0 VPWR VGND sg13g2_decap_8
XFILLER_39_843 VPWR VGND sg13g2_decap_8
Xu_ppwm_u_ex__1128_ net46 VGND VPWR u_ppwm_u_ex__1128_/D hold297/A clknet_5_4__leaf_clk
+ sg13g2_dfrbpq_2
Xu_ppwm_u_global_counter__117_ u_ppwm_u_global_counter__118_/B net494 u_ppwm_u_global_counter__119_/B
+ VPWR VGND sg13g2_nand2_1
XFILLER_26_515 VPWR VGND sg13g2_decap_8
Xu_ppwm_u_ex__1059_ VGND VPWR u_ppwm_u_ex__1052_/Y u_ppwm_u_ex__1054_/Y u_ppwm_u_ex__1061_/A
+ u_ppwm_u_ex__1058_/Y sg13g2_a21oi_1
XFILLER_34_570 VPWR VGND sg13g2_decap_8
XFILLER_22_721 VPWR VGND sg13g2_decap_8
Xu_ppwm_u_pwm__250__212 VPWR VGND net212 sg13g2_tiehi
XFILLER_22_798 VPWR VGND sg13g2_decap_8
XFILLER_5_419 VPWR VGND sg13g2_decap_8
XFILLER_49_607 VPWR VGND sg13g2_decap_8
XFILLER_1_636 VPWR VGND sg13g2_decap_8
XFILLER_0_157 VPWR VGND sg13g2_decap_8
XFILLER_45_802 VPWR VGND sg13g2_decap_8
XFILLER_28_53 VPWR VGND sg13g2_fill_2
XFILLER_45_879 VPWR VGND sg13g2_decap_8
XFILLER_17_559 VPWR VGND sg13g2_decap_8
XFILLER_32_529 VPWR VGND sg13g2_decap_8
XFILLER_44_96 VPWR VGND sg13g2_fill_2
XFILLER_13_721 VPWR VGND sg13g2_decap_8
XFILLER_25_592 VPWR VGND sg13g2_decap_8
XFILLER_40_562 VPWR VGND sg13g2_decap_8
XFILLER_8_202 VPWR VGND sg13g2_fill_1
XFILLER_9_703 VPWR VGND sg13g2_decap_8
XFILLER_8_246 VPWR VGND sg13g2_decap_4
XFILLER_12_297 VPWR VGND sg13g2_decap_4
XFILLER_13_798 VPWR VGND sg13g2_decap_8
Xu_ppwm_u_ex__1124__54 VPWR VGND net54 sg13g2_tiehi
Xu_ppwm_u_mem__0711_ VPWR u_ppwm_u_mem__0711_/Y net307 VGND sg13g2_inv_1
XFILLER_5_24 VPWR VGND sg13g2_fill_1
XFILLER_4_452 VPWR VGND sg13g2_decap_8
XFILLER_5_986 VPWR VGND sg13g2_decap_8
Xu_ppwm_u_mem__0642_ VPWR u_ppwm_u_mem__0642_/Y net326 VGND sg13g2_inv_1
XFILLER_36_802 VPWR VGND sg13g2_decap_8
XFILLER_48_695 VPWR VGND sg13g2_decap_8
XFILLER_47_161 VPWR VGND sg13g2_fill_2
Xu_ppwm_u_mem__1125_ net101 VGND VPWR u_ppwm_u_mem__1125_/D hold125/A clknet_5_26__leaf_clk
+ sg13g2_dfrbpq_1
XFILLER_39_1018 VPWR VGND sg13g2_decap_8
XFILLER_36_879 VPWR VGND sg13g2_decap_8
XFILLER_23_518 VPWR VGND sg13g2_decap_8
Xu_ppwm_u_mem__1056_ VGND VPWR u_ppwm_u_mem__0604_/Y net388 u_ppwm_u_mem__1198_/D
+ u_ppwm_u_mem__1055_/Y sg13g2_a21oi_1
XFILLER_31_551 VPWR VGND sg13g2_decap_8
Xu_ppwm_u_mem__0909_ net500 VPWR u_ppwm_u_mem__0909_/Y VGND net327 net414 sg13g2_o21ai_1
XFILLER_8_780 VPWR VGND sg13g2_decap_8
Xhold202 hold202/A VPWR VGND net585 sg13g2_dlygate4sd3_1
Xhold224 hold224/A VPWR VGND net607 sg13g2_dlygate4sd3_1
Xhold213 hold213/A VPWR VGND net596 sg13g2_dlygate4sd3_1
Xhold235 hold235/A VPWR VGND net618 sg13g2_dlygate4sd3_1
Xhold257 hold257/A VPWR VGND net640 sg13g2_dlygate4sd3_1
Xhold268 hold268/A VPWR VGND net651 sg13g2_dlygate4sd3_1
Xhold246 hold246/A VPWR VGND net629 sg13g2_dlygate4sd3_1
Xu_ppwm_u_ex__0628_ net496 VPWR u_ppwm_u_ex__0628_/Y VGND u_ppwm_u_ex__0637_/A u_ppwm_u_ex__0627_/Y
+ sg13g2_o21ai_1
Xhold279 hold279/A VPWR VGND net662 sg13g2_dlygate4sd3_1
XFILLER_39_640 VPWR VGND sg13g2_decap_8
XFILLER_22_1022 VPWR VGND sg13g2_decap_8
XFILLER_27_813 VPWR VGND sg13g2_decap_8
XFILLER_26_356 VPWR VGND sg13g2_fill_1
XFILLER_14_11 VPWR VGND sg13g2_decap_8
XFILLER_22_595 VPWR VGND sg13g2_decap_8
XFILLER_10_768 VPWR VGND sg13g2_decap_8
XFILLER_14_88 VPWR VGND sg13g2_fill_1
XFILLER_2_956 VPWR VGND sg13g2_decap_8
XFILLER_1_433 VPWR VGND sg13g2_decap_8
XFILLER_49_404 VPWR VGND sg13g2_decap_8
XFILLER_7_1016 VPWR VGND sg13g2_decap_8
XFILLER_7_1027 VPWR VGND sg13g2_fill_2
XFILLER_18_802 VPWR VGND sg13g2_decap_8
XFILLER_17_301 VPWR VGND sg13g2_fill_2
XFILLER_29_172 VPWR VGND sg13g2_decap_4
XFILLER_18_879 VPWR VGND sg13g2_decap_8
XFILLER_45_676 VPWR VGND sg13g2_decap_8
XFILLER_44_142 VPWR VGND sg13g2_fill_1
XFILLER_33_816 VPWR VGND sg13g2_decap_8
Xu_ppwm_u_mem__1132__87 VPWR VGND net87 sg13g2_tiehi
XFILLER_32_337 VPWR VGND sg13g2_decap_8
XFILLER_41_860 VPWR VGND sg13g2_decap_8
XFILLER_9_500 VPWR VGND sg13g2_decap_8
XFILLER_40_370 VPWR VGND sg13g2_decap_8
XFILLER_13_595 VPWR VGND sg13g2_decap_8
XFILLER_9_577 VPWR VGND sg13g2_decap_8
XFILLER_5_783 VPWR VGND sg13g2_decap_8
Xu_ppwm_u_mem__0625_ VPWR u_ppwm_u_mem__0625_/Y net582 VGND sg13g2_inv_1
XFILLER_49_971 VPWR VGND sg13g2_decap_8
XFILLER_27_109 VPWR VGND sg13g2_fill_1
XFILLER_48_492 VPWR VGND sg13g2_decap_8
XFILLER_24_838 VPWR VGND sg13g2_decap_8
XFILLER_36_676 VPWR VGND sg13g2_decap_8
Xu_ppwm_u_mem__1108_ net134 VGND VPWR u_ppwm_u_mem__1108_/D hold124/A clknet_5_15__leaf_clk
+ sg13g2_dfrbpq_1
Xu_ppwm_u_mem__1039_ net498 VPWR u_ppwm_u_mem__1039_/Y VGND hold131/A net405 sg13g2_o21ai_1
XFILLER_32_893 VPWR VGND sg13g2_decap_8
Xfanout501 net502 net501 VPWR VGND sg13g2_buf_8
XFILLER_47_919 VPWR VGND sg13g2_decap_8
XFILLER_27_610 VPWR VGND sg13g2_decap_8
Xclkbuf_5_2__f_clk clknet_4_1_0_clk clknet_5_2__leaf_clk VPWR VGND sg13g2_buf_8
XFILLER_27_687 VPWR VGND sg13g2_decap_8
XFILLER_42_657 VPWR VGND sg13g2_decap_8
XFILLER_30_808 VPWR VGND sg13g2_decap_8
XFILLER_23_882 VPWR VGND sg13g2_decap_8
XFILLER_10_565 VPWR VGND sg13g2_decap_8
XFILLER_6_547 VPWR VGND sg13g2_decap_8
XFILLER_9_0 VPWR VGND sg13g2_fill_1
XFILLER_2_753 VPWR VGND sg13g2_decap_8
XFILLER_2_25 VPWR VGND sg13g2_decap_8
XFILLER_49_234 VPWR VGND sg13g2_fill_1
XFILLER_2_36 VPWR VGND sg13g2_fill_2
XFILLER_2_47 VPWR VGND sg13g2_fill_2
XFILLER_46_930 VPWR VGND sg13g2_decap_8
XFILLER_45_473 VPWR VGND sg13g2_decap_8
XFILLER_17_131 VPWR VGND sg13g2_fill_2
XFILLER_18_676 VPWR VGND sg13g2_decap_8
XFILLER_33_613 VPWR VGND sg13g2_decap_8
XFILLER_32_112 VPWR VGND sg13g2_decap_8
Xu_ppwm_u_ex__0962_ u_ppwm_u_ex__0962_/Y net441 net362 VPWR VGND sg13g2_nand2_1
Xu_ppwm_u_ex__0893_ u_ppwm_u_ex__0983_/A VPWR u_ppwm_u_ex__0893_/Y VGND u_ppwm_u_ex__0827_/D
+ u_ppwm_u_ex__0847_/B sg13g2_o21ai_1
XFILLER_12_1010 VPWR VGND sg13g2_decap_8
XFILLER_5_580 VPWR VGND sg13g2_decap_8
Xu_ppwm_u_mem__0608_ VPWR u_ppwm_u_mem__0608_/Y net336 VGND sg13g2_inv_1
XFILLER_37_952 VPWR VGND sg13g2_decap_8
XFILLER_36_451 VPWR VGND sg13g2_decap_4
XFILLER_24_635 VPWR VGND sg13g2_decap_8
XFILLER_32_690 VPWR VGND sg13g2_decap_8
XFILLER_20_874 VPWR VGND sg13g2_decap_8
XFILLER_11_12 VPWR VGND sg13g2_decap_8
Xclkbuf_4_2_0_clk clknet_0_clk clknet_4_2_0_clk VPWR VGND sg13g2_buf_8
XFILLER_3_539 VPWR VGND sg13g2_decap_8
Xfanout342 net343 net342 VPWR VGND sg13g2_buf_8
Xfanout364 fanout367/A net364 VPWR VGND sg13g2_buf_8
Xfanout375 net376 net375 VPWR VGND sg13g2_buf_8
Xfanout353 net354 net353 VPWR VGND sg13g2_buf_8
XFILLER_47_716 VPWR VGND sg13g2_decap_8
XFILLER_4_1019 VPWR VGND sg13g2_decap_8
XFILLER_19_418 VPWR VGND sg13g2_fill_1
Xfanout386 net404 net386 VPWR VGND sg13g2_buf_2
Xfanout397 net404 net397 VPWR VGND sg13g2_buf_2
XFILLER_46_248 VPWR VGND sg13g2_decap_8
XFILLER_28_952 VPWR VGND sg13g2_decap_8
XFILLER_43_911 VPWR VGND sg13g2_decap_8
XFILLER_14_101 VPWR VGND sg13g2_decap_8
XFILLER_27_484 VPWR VGND sg13g2_decap_8
XFILLER_43_988 VPWR VGND sg13g2_decap_8
XFILLER_42_454 VPWR VGND sg13g2_decap_8
XFILLER_42_443 VPWR VGND sg13g2_fill_2
XFILLER_15_668 VPWR VGND sg13g2_decap_8
XFILLER_30_605 VPWR VGND sg13g2_decap_8
XFILLER_35_1010 VPWR VGND sg13g2_decap_8
Xu_ppwm_u_pwm__201_ u_ppwm_u_pwm__200_/Y VPWR u_ppwm_u_pwm__230_/A VGND hold192/A
+ u_ppwm_u_pwm__202_/B sg13g2_o21ai_1
Xu_ppwm_u_mem__0890_ VGND VPWR u_ppwm_u_mem__0687_/Y net398 u_ppwm_u_mem__1115_/D
+ u_ppwm_u_mem__0889_/Y sg13g2_a21oi_1
XFILLER_7_834 VPWR VGND sg13g2_decap_8
XFILLER_11_885 VPWR VGND sg13g2_decap_8
Xu_ppwm_u_pwm__132_ VPWR u_ppwm_u_pwm__132_/Y net263 VGND sg13g2_inv_1
XFILLER_2_550 VPWR VGND sg13g2_decap_8
XFILLER_35_7 VPWR VGND sg13g2_decap_8
XFILLER_42_1014 VPWR VGND sg13g2_decap_8
Xu_ppwm_u_global_counter__150_ u_ppwm_u_global_counter__150_/Y net480 u_ppwm_u_global_counter__150_/B
+ VPWR VGND sg13g2_nand2_1
Xu_ppwm_u_ex__1092_ net431 net363 u_ppwm_u_ex__1092_/X VPWR VGND sg13g2_and2_1
XFILLER_38_749 VPWR VGND sg13g2_decap_8
XFILLER_19_963 VPWR VGND sg13g2_decap_8
XFILLER_45_270 VPWR VGND sg13g2_decap_8
XFILLER_34_955 VPWR VGND sg13g2_decap_8
XFILLER_21_638 VPWR VGND sg13g2_decap_8
XFILLER_33_465 VPWR VGND sg13g2_decap_4
XFILLER_33_487 VPWR VGND sg13g2_decap_8
Xu_ppwm_u_ex__0945_ u_ppwm_u_ex__0958_/C hold276/A net362 VPWR VGND sg13g2_xnor2_1
XFILLER_20_159 VPWR VGND sg13g2_decap_4
Xu_ppwm_u_ex__0876_ VGND VPWR u_ppwm_u_ex__0769_/A net376 u_ppwm_u_ex__0898_/B u_ppwm_u_ex__0875_/Y
+ sg13g2_a21oi_1
XFILLER_29_738 VPWR VGND sg13g2_decap_8
XFILLER_44_719 VPWR VGND sg13g2_decap_8
XFILLER_25_900 VPWR VGND sg13g2_decap_8
XFILLER_43_218 VPWR VGND sg13g2_fill_2
XFILLER_19_1005 VPWR VGND sg13g2_decap_8
XFILLER_24_432 VPWR VGND sg13g2_decap_8
XFILLER_25_977 VPWR VGND sg13g2_decap_8
XFILLER_40_947 VPWR VGND sg13g2_decap_8
XFILLER_22_11 VPWR VGND sg13g2_fill_1
XFILLER_20_671 VPWR VGND sg13g2_decap_8
XFILLER_22_66 VPWR VGND sg13g2_fill_2
Xu_ppwm_u_mem__1108__134 VPWR VGND net134 sg13g2_tiehi
XFILLER_4_837 VPWR VGND sg13g2_decap_8
XFILLER_47_513 VPWR VGND sg13g2_decap_8
XFILLER_16_933 VPWR VGND sg13g2_decap_8
XFILLER_15_432 VPWR VGND sg13g2_decap_8
XFILLER_15_443 VPWR VGND sg13g2_fill_2
XFILLER_43_785 VPWR VGND sg13g2_decap_8
XFILLER_31_936 VPWR VGND sg13g2_decap_8
Xu_ppwm_u_mem__0942_ VGND VPWR u_ppwm_u_mem__0661_/Y net414 u_ppwm_u_mem__1141_/D
+ u_ppwm_u_mem__0941_/Y sg13g2_a21oi_1
Xu_ppwm_u_ex__0730_ u_ppwm_u_ex__0730_/Y hold246/A net438 VPWR VGND sg13g2_nand2b_1
XFILLER_8_68 VPWR VGND sg13g2_fill_1
XFILLER_7_631 VPWR VGND sg13g2_decap_8
XFILLER_11_682 VPWR VGND sg13g2_decap_8
Xu_ppwm_u_ex__0661_ u_ppwm_u_ex__0660_/Y VPWR u_ppwm_u_ex__0661_/Y VGND net448 u_ppwm_u_ex__0606_/Y
+ sg13g2_o21ai_1
XFILLER_6_141 VPWR VGND sg13g2_fill_2
XFILLER_6_130 VPWR VGND sg13g2_decap_8
Xu_ppwm_u_mem__0873_ net489 VPWR u_ppwm_u_mem__0873_/Y VGND hold124/A net398 sg13g2_o21ai_1
Xu_ppwm_u_ex__0592_ VPWR fanout361/A net369 VGND sg13g2_inv_1
Xu_ppwm_u_global_counter__133_ u_ppwm_u_global_counter__133_/Y net494 u_ppwm_u_global_counter__141_/D
+ VPWR VGND sg13g2_nand2_1
XFILLER_38_546 VPWR VGND sg13g2_decap_8
Xu_ppwm_u_ex__1075_ u_ppwm_u_ex__1075_/A u_ppwm_u_ex__1075_/B u_ppwm_u_ex__1138_/D
+ VPWR VGND sg13g2_nor2_1
XFILLER_19_760 VPWR VGND sg13g2_decap_8
XFILLER_22_903 VPWR VGND sg13g2_decap_8
XFILLER_34_752 VPWR VGND sg13g2_decap_8
XFILLER_33_262 VPWR VGND sg13g2_fill_1
Xu_ppwm_u_ex__0928_ net362 VPWR u_ppwm_u_ex__0960_/A VGND net443 net445 sg13g2_o21ai_1
Xu_ppwm_u_ex__0859_ u_ppwm_u_ex__0859_/Y net356 hold246/A net358 hold272/A VPWR VGND
+ sg13g2_a22oi_1
XFILLER_1_818 VPWR VGND sg13g2_decap_8
XFILLER_0_317 VPWR VGND sg13g2_decap_4
XFILLER_29_535 VPWR VGND sg13g2_decap_8
XFILLER_17_11 VPWR VGND sg13g2_decap_8
XFILLER_44_516 VPWR VGND sg13g2_decap_8
XFILLER_16_207 VPWR VGND sg13g2_decap_8
XFILLER_16_229 VPWR VGND sg13g2_fill_2
XFILLER_13_903 VPWR VGND sg13g2_decap_8
XFILLER_25_774 VPWR VGND sg13g2_decap_8
XFILLER_40_744 VPWR VGND sg13g2_decap_8
XFILLER_12_446 VPWR VGND sg13g2_fill_1
XFILLER_33_21 VPWR VGND sg13g2_decap_8
XFILLER_4_634 VPWR VGND sg13g2_decap_8
XFILLER_0_840 VPWR VGND sg13g2_decap_8
XFILLER_48_800 VPWR VGND sg13g2_decap_8
Xhold6 hold6/A VPWR VGND net223 sg13g2_dlygate4sd3_1
Xu_ppwm_u_mem__1210_ net484 VGND VPWR net2 hold1/A clknet_5_2__leaf_clk sg13g2_dfrbpq_1
XFILLER_48_877 VPWR VGND sg13g2_decap_8
Xu_ppwm_u_mem__1141_ net187 VGND VPWR u_ppwm_u_mem__1141_/D hold16/A clknet_5_30__leaf_clk
+ sg13g2_dfrbpq_1
XFILLER_47_387 VPWR VGND sg13g2_fill_1
XFILLER_35_527 VPWR VGND sg13g2_decap_8
XFILLER_16_730 VPWR VGND sg13g2_decap_8
Xu_ppwm_u_mem__1072_ net381 u_ppwm_u_mem__1080_/C u_ppwm_u_mem__1077_/S VPWR VGND
+ sg13g2_nor2_1
XFILLER_43_582 VPWR VGND sg13g2_decap_8
XFILLER_30_221 VPWR VGND sg13g2_fill_1
XFILLER_31_733 VPWR VGND sg13g2_decap_8
XFILLER_30_265 VPWR VGND sg13g2_decap_8
Xu_ppwm_u_mem__0925_ net501 VPWR u_ppwm_u_mem__0925_/Y VGND hold147/A net414 sg13g2_o21ai_1
XFILLER_8_962 VPWR VGND sg13g2_decap_8
Xu_ppwm_u_ex__0713_ u_ppwm_u_ex__0712_/Y VPWR u_ppwm_u_ex__0713_/Y VGND u_ppwm_u_ex__0707_/Y
+ u_ppwm_u_ex__0711_/Y sg13g2_o21ai_1
Xu_ppwm_u_mem__0856_ VGND VPWR u_ppwm_u_mem__0704_/Y net394 u_ppwm_u_mem__1098_/D
+ u_ppwm_u_mem__0855_/Y sg13g2_a21oi_1
Xu_ppwm_u_ex__0644_ u_ppwm_u_ex__0644_/B u_ppwm_u_ex__0648_/B u_ppwm_u_ex__0644_/Y
+ VPWR VGND u_ppwm_u_ex__0652_/B sg13g2_nand3b_1
Xu_ppwm_u_ex__0575_ VPWR u_ppwm_u_ex__0575_/Y net437 VGND sg13g2_inv_1
Xu_ppwm_u_mem__0787_ u_ppwm_u_mem__0787_/Y hold55/A net469 VPWR VGND sg13g2_nand2_1
XFILLER_39_822 VPWR VGND sg13g2_decap_8
Xu_ppwm_u_global_counter__116_ net427 u_ppwm_u_global_counter__116_/C net426 u_ppwm_u_global_counter__119_/B
+ VPWR VGND sg13g2_nand3_1
XFILLER_39_899 VPWR VGND sg13g2_decap_8
Xu_ppwm_u_ex__1127_ net48 VGND VPWR u_ppwm_u_ex__1127_/D hold294/A clknet_5_5__leaf_clk
+ sg13g2_dfrbpq_2
XFILLER_0_1022 VPWR VGND sg13g2_decap_8
Xu_ppwm_u_ex__1058_ fanout343/A u_ppwm_u_ex__1058_/C u_ppwm_u_ex__1058_/A u_ppwm_u_ex__1058_/Y
+ VPWR VGND sg13g2_nand3_1
XFILLER_22_700 VPWR VGND sg13g2_decap_8
XFILLER_21_232 VPWR VGND sg13g2_decap_8
XFILLER_22_777 VPWR VGND sg13g2_decap_8
Xu_ppwm_u_ex__1133__55 VPWR VGND net55 sg13g2_tiehi
XFILLER_1_615 VPWR VGND sg13g2_decap_8
XFILLER_0_136 VPWR VGND sg13g2_decap_8
Xu_ppwm_u_mem__1129__93 VPWR VGND net93 sg13g2_tiehi
XFILLER_28_43 VPWR VGND sg13g2_fill_1
XFILLER_29_332 VPWR VGND sg13g2_decap_8
XFILLER_17_538 VPWR VGND sg13g2_decap_8
XFILLER_45_858 VPWR VGND sg13g2_decap_8
XFILLER_44_20 VPWR VGND sg13g2_fill_2
XFILLER_13_700 VPWR VGND sg13g2_decap_8
XFILLER_32_508 VPWR VGND sg13g2_decap_8
XFILLER_12_210 VPWR VGND sg13g2_fill_2
XFILLER_25_571 VPWR VGND sg13g2_decap_8
XFILLER_40_541 VPWR VGND sg13g2_decap_8
XFILLER_13_777 VPWR VGND sg13g2_decap_8
XFILLER_9_759 VPWR VGND sg13g2_decap_8
Xu_ppwm_u_mem__0710_ VPWR u_ppwm_u_mem__0710_/Y net338 VGND sg13g2_inv_1
XFILLER_5_965 VPWR VGND sg13g2_decap_8
XFILLER_5_36 VPWR VGND sg13g2_fill_1
XFILLER_4_431 VPWR VGND sg13g2_decap_8
Xu_ppwm_u_mem__0641_ VPWR u_ppwm_u_mem__0641_/Y net315 VGND sg13g2_inv_1
XFILLER_48_674 VPWR VGND sg13g2_decap_8
Xu_ppwm_u_mem__1124_ net103 VGND VPWR net290 hold72/A clknet_5_26__leaf_clk sg13g2_dfrbpq_1
XFILLER_36_858 VPWR VGND sg13g2_decap_8
Xu_ppwm_u_mem__1055_ net481 VPWR u_ppwm_u_mem__1055_/Y VGND net542 net388 sg13g2_o21ai_1
XFILLER_44_880 VPWR VGND sg13g2_decap_8
XFILLER_31_530 VPWR VGND sg13g2_decap_8
Xu_ppwm_u_mem__0908_ VGND VPWR u_ppwm_u_mem__0678_/Y net401 hold73/A u_ppwm_u_mem__0907_/Y
+ sg13g2_a21oi_1
Xhold214 hold214/A VPWR VGND net597 sg13g2_dlygate4sd3_1
Xhold225 hold225/A VPWR VGND net608 sg13g2_dlygate4sd3_1
Xhold203 hold203/A VPWR VGND net586 sg13g2_dlygate4sd3_1
Xu_ppwm_u_mem__0839_ net485 VPWR u_ppwm_u_mem__0839_/Y VGND hold90/A net394 sg13g2_o21ai_1
Xhold236 hold236/A VPWR VGND net619 sg13g2_dlygate4sd3_1
Xhold247 hold247/A VPWR VGND net630 sg13g2_dlygate4sd3_1
Xhold269 hold269/A VPWR VGND net652 sg13g2_dlygate4sd3_1
Xu_ppwm_u_ex__0627_ net475 VPWR u_ppwm_u_ex__0627_/Y VGND net377 u_ppwm_u_ex__0652_/B
+ sg13g2_o21ai_1
Xhold258 hold258/A VPWR VGND net641 sg13g2_dlygate4sd3_1
XFILLER_22_1001 VPWR VGND sg13g2_decap_8
XFILLER_39_696 VPWR VGND sg13g2_decap_8
XFILLER_26_324 VPWR VGND sg13g2_fill_2
XFILLER_27_869 VPWR VGND sg13g2_decap_8
XFILLER_42_839 VPWR VGND sg13g2_decap_8
XFILLER_35_891 VPWR VGND sg13g2_decap_8
XFILLER_22_574 VPWR VGND sg13g2_decap_8
XFILLER_10_747 VPWR VGND sg13g2_decap_8
XFILLER_6_729 VPWR VGND sg13g2_decap_8
XFILLER_30_22 VPWR VGND sg13g2_decap_8
XFILLER_5_239 VPWR VGND sg13g2_fill_2
XFILLER_2_935 VPWR VGND sg13g2_decap_8
XFILLER_1_412 VPWR VGND sg13g2_decap_8
XFILLER_1_489 VPWR VGND sg13g2_decap_8
XFILLER_17_313 VPWR VGND sg13g2_fill_2
XFILLER_45_655 VPWR VGND sg13g2_decap_8
XFILLER_17_346 VPWR VGND sg13g2_decap_8
XFILLER_18_858 VPWR VGND sg13g2_decap_8
XFILLER_13_574 VPWR VGND sg13g2_decap_8
XFILLER_9_556 VPWR VGND sg13g2_decap_8
XFILLER_5_762 VPWR VGND sg13g2_decap_8
XFILLER_4_283 VPWR VGND sg13g2_fill_2
Xu_ppwm_u_mem__0624_ VPWR u_ppwm_u_mem__0624_/Y net524 VGND sg13g2_inv_1
XFILLER_45_1012 VPWR VGND sg13g2_decap_8
XFILLER_49_950 VPWR VGND sg13g2_decap_8
XFILLER_48_471 VPWR VGND sg13g2_decap_8
XFILLER_36_655 VPWR VGND sg13g2_decap_8
Xu_ppwm_u_mem__1107_ net136 VGND VPWR net279 hold61/A clknet_5_15__leaf_clk sg13g2_dfrbpq_1
XFILLER_24_817 VPWR VGND sg13g2_decap_8
Xu_ppwm_u_mem__1038_ VGND VPWR u_ppwm_u_mem__0613_/Y net405 u_ppwm_u_mem__1189_/D
+ u_ppwm_u_mem__1037_/Y sg13g2_a21oi_1
XFILLER_32_872 VPWR VGND sg13g2_decap_8
Xu_ppwm_u_mem__1180__161 VPWR VGND net161 sg13g2_tiehi
Xfanout502 net506 net502 VPWR VGND sg13g2_buf_8
XFILLER_39_493 VPWR VGND sg13g2_decap_8
XFILLER_26_132 VPWR VGND sg13g2_decap_4
XFILLER_27_666 VPWR VGND sg13g2_decap_8
XFILLER_42_636 VPWR VGND sg13g2_decap_8
XFILLER_23_861 VPWR VGND sg13g2_decap_8
XFILLER_22_360 VPWR VGND sg13g2_fill_2
XFILLER_10_544 VPWR VGND sg13g2_decap_8
XFILLER_6_526 VPWR VGND sg13g2_decap_8
XFILLER_2_732 VPWR VGND sg13g2_decap_8
XFILLER_29_1018 VPWR VGND sg13g2_decap_8
XFILLER_49_279 VPWR VGND sg13g2_decap_4
XFILLER_46_986 VPWR VGND sg13g2_decap_8
XFILLER_45_452 VPWR VGND sg13g2_decap_8
XFILLER_18_655 VPWR VGND sg13g2_decap_8
Xu_ppwm_u_ex__0961_ VGND VPWR u_ppwm_u_ex__0890_/X u_ppwm_u_ex__0958_/Y u_ppwm_u_ex__0965_/A
+ u_ppwm_u_ex__0960_/Y sg13g2_a21oi_1
XFILLER_33_669 VPWR VGND sg13g2_decap_8
Xu_ppwm_u_ex__0892_ u_ppwm_u_ex__0889_/Y u_ppwm_u_ex__0886_/Y u_ppwm_u_ex__0891_/Y
+ u_ppwm_u_ex__0905_/B VPWR VGND sg13g2_a21o_1
Xu_ppwm_u_mem__1164__112 VPWR VGND net112 sg13g2_tiehi
XFILLER_9_375 VPWR VGND sg13g2_decap_4
XFILLER_9_364 VPWR VGND sg13g2_fill_2
Xu_ppwm_u_mem__0607_ VPWR u_ppwm_u_mem__0607_/Y net247 VGND sg13g2_inv_1
XFILLER_37_931 VPWR VGND sg13g2_decap_8
XFILLER_36_430 VPWR VGND sg13g2_fill_1
XFILLER_24_614 VPWR VGND sg13g2_decap_8
XFILLER_20_853 VPWR VGND sg13g2_decap_8
XFILLER_3_518 VPWR VGND sg13g2_decap_8
XFILLER_11_79 VPWR VGND sg13g2_decap_4
Xfanout343 fanout343/A net343 VPWR VGND sg13g2_buf_2
Xfanout365 net367 net365 VPWR VGND sg13g2_buf_8
Xfanout354 fanout354/A net354 VPWR VGND sg13g2_buf_8
Xfanout398 net403 net398 VPWR VGND sg13g2_buf_8
Xfanout376 net377 net376 VPWR VGND sg13g2_buf_8
Xfanout387 net388 net387 VPWR VGND sg13g2_buf_8
XFILLER_28_931 VPWR VGND sg13g2_decap_8
XFILLER_36_21 VPWR VGND sg13g2_decap_8
XFILLER_27_463 VPWR VGND sg13g2_decap_8
XFILLER_36_32 VPWR VGND sg13g2_fill_1
XFILLER_43_967 VPWR VGND sg13g2_decap_8
XFILLER_15_647 VPWR VGND sg13g2_decap_8
XFILLER_36_98 VPWR VGND sg13g2_fill_1
Xu_ppwm_u_pwm__200_ u_ppwm_u_pwm__200_/Y u_ppwm_u_pwm__200_/A hold210/A VPWR VGND
+ sg13g2_nand2_1
XFILLER_7_813 VPWR VGND sg13g2_decap_8
XFILLER_11_864 VPWR VGND sg13g2_decap_8
XFILLER_10_374 VPWR VGND sg13g2_fill_1
Xu_ppwm_u_pwm__131_ VPWR u_ppwm_u_pwm__131_/Y net287 VGND sg13g2_inv_1
XFILLER_38_728 VPWR VGND sg13g2_decap_8
Xu_ppwm_u_ex__1091_ u_ppwm_u_ex__1090_/X VPWR u_ppwm_u_ex__1091_/Y VGND u_ppwm_u_ex__1042_/B
+ u_ppwm_u_ex__1088_/X sg13g2_o21ai_1
XFILLER_19_942 VPWR VGND sg13g2_decap_8
XFILLER_46_783 VPWR VGND sg13g2_decap_8
XFILLER_34_934 VPWR VGND sg13g2_decap_8
XFILLER_33_455 VPWR VGND sg13g2_fill_1
XFILLER_21_617 VPWR VGND sg13g2_decap_8
XFILLER_33_477 VPWR VGND sg13g2_fill_1
Xu_ppwm_u_ex__0944_ VGND VPWR u_ppwm_u_ex__0927_/A u_ppwm_u_ex__0930_/Y u_ppwm_u_ex__0946_/A
+ u_ppwm_u_ex__0925_/Y sg13g2_a21oi_1
Xu_ppwm_u_ex__0875_ hold276/A net376 u_ppwm_u_ex__0875_/Y VPWR VGND sg13g2_nor2_1
XFILLER_6_890 VPWR VGND sg13g2_decap_8
XFILLER_28_205 VPWR VGND sg13g2_decap_4
XFILLER_29_717 VPWR VGND sg13g2_decap_8
XFILLER_25_956 VPWR VGND sg13g2_decap_8
XFILLER_40_926 VPWR VGND sg13g2_decap_8
XFILLER_19_1028 VPWR VGND sg13g2_fill_1
XFILLER_24_488 VPWR VGND sg13g2_decap_8
XFILLER_12_639 VPWR VGND sg13g2_decap_8
XFILLER_20_650 VPWR VGND sg13g2_decap_8
XFILLER_22_23 VPWR VGND sg13g2_fill_2
XFILLER_4_816 VPWR VGND sg13g2_decap_8
XFILLER_19_227 VPWR VGND sg13g2_decap_8
XFILLER_47_569 VPWR VGND sg13g2_decap_8
XFILLER_35_709 VPWR VGND sg13g2_decap_8
XFILLER_15_400 VPWR VGND sg13g2_fill_1
XFILLER_16_912 VPWR VGND sg13g2_decap_8
XFILLER_27_260 VPWR VGND sg13g2_decap_8
XFILLER_43_764 VPWR VGND sg13g2_decap_8
XFILLER_16_989 VPWR VGND sg13g2_decap_8
XFILLER_31_915 VPWR VGND sg13g2_decap_8
Xu_ppwm_u_mem__0941_ net502 VPWR u_ppwm_u_mem__0941_/Y VGND net229 net411 sg13g2_o21ai_1
XFILLER_7_610 VPWR VGND sg13g2_decap_8
XFILLER_11_661 VPWR VGND sg13g2_decap_8
Xu_ppwm_u_mem__0872_ VGND VPWR u_ppwm_u_mem__0696_/Y net399 u_ppwm_u_mem__1106_/D
+ u_ppwm_u_mem__0871_/Y sg13g2_a21oi_1
Xu_ppwm_u_ex__0660_ net428 net450 u_ppwm_u_ex__0660_/Y VPWR VGND sg13g2_nor2b_1
XFILLER_10_193 VPWR VGND sg13g2_decap_8
XFILLER_7_687 VPWR VGND sg13g2_decap_8
Xu_ppwm_u_ex__0591_ net367 u_ppwm_u_ex__0925_/B VPWR VGND sg13g2_inv_4
XFILLER_3_882 VPWR VGND sg13g2_decap_8
XFILLER_26_4 VPWR VGND sg13g2_decap_8
Xu_ppwm_u_global_counter__132_ net425 u_ppwm_u_global_counter__132_/C net608 u_ppwm_u_global_counter__141_/D
+ VPWR VGND u_ppwm_u_global_counter__132_/D sg13g2_nand4_1
XFILLER_38_525 VPWR VGND sg13g2_decap_8
Xclkbuf_4_1_0_clk clknet_0_clk clknet_4_1_0_clk VPWR VGND sg13g2_buf_8
Xu_ppwm_u_ex__1074_ net497 VPWR u_ppwm_u_ex__1075_/B VGND net433 net341 sg13g2_o21ai_1
XFILLER_46_580 VPWR VGND sg13g2_decap_8
XFILLER_34_731 VPWR VGND sg13g2_decap_8
XFILLER_21_403 VPWR VGND sg13g2_decap_4
XFILLER_22_959 VPWR VGND sg13g2_decap_8
Xu_ppwm_u_ex__0927_ VPWR u_ppwm_u_ex__0958_/A u_ppwm_u_ex__0927_/A VGND sg13g2_inv_1
Xu_ppwm_u_ex__0858_ u_ppwm_u_ex__0857_/Y VPWR u_ppwm_u_ex__0863_/C VGND u_ppwm_u_ex__0854_/Y
+ u_ppwm_u_ex__0888_/A sg13g2_o21ai_1
Xu_ppwm_u_ex__0789_ fanout349/A u_ppwm_u_ex__0789_/A u_ppwm_u_ex__0845_/C VPWR VGND
+ sg13g2_nand2_2
XFILLER_29_514 VPWR VGND sg13g2_decap_8
XFILLER_25_753 VPWR VGND sg13g2_decap_8
XFILLER_40_723 VPWR VGND sg13g2_decap_8
Xu_ppwm_u_ex__1136__42 VPWR VGND net42 sg13g2_tiehi
XFILLER_13_959 VPWR VGND sg13g2_decap_8
XFILLER_8_429 VPWR VGND sg13g2_fill_1
XFILLER_21_981 VPWR VGND sg13g2_decap_8
XFILLER_4_613 VPWR VGND sg13g2_decap_8
XFILLER_3_101 VPWR VGND sg13g2_fill_2
Xhold7 hold7/A VPWR VGND net224 sg13g2_dlygate4sd3_1
XFILLER_0_896 VPWR VGND sg13g2_decap_8
XFILLER_48_856 VPWR VGND sg13g2_decap_8
Xu_ppwm_u_mem__1140_ net189 VGND VPWR u_ppwm_u_mem__1140_/D hold34/A clknet_5_30__leaf_clk
+ sg13g2_dfrbpq_1
Xu_ppwm_u_mem__1071_ net311 hold252/A net560 u_ppwm_u_mem__1080_/C VPWR VGND net626
+ sg13g2_nand4_1
XFILLER_35_506 VPWR VGND sg13g2_decap_8
XFILLER_43_561 VPWR VGND sg13g2_decap_8
XFILLER_16_786 VPWR VGND sg13g2_decap_8
XFILLER_31_712 VPWR VGND sg13g2_decap_8
XFILLER_15_285 VPWR VGND sg13g2_decap_8
XFILLER_30_233 VPWR VGND sg13g2_decap_4
XFILLER_8_941 VPWR VGND sg13g2_decap_8
XFILLER_31_789 VPWR VGND sg13g2_decap_8
Xu_ppwm_u_mem__0924_ VGND VPWR u_ppwm_u_mem__0670_/Y net418 u_ppwm_u_mem__1132_/D
+ u_ppwm_u_mem__0923_/Y sg13g2_a21oi_1
Xu_ppwm_u_ex__0712_ u_ppwm_u_ex__0712_/Y u_ppwm_u_ex__0598_/Y hold278/A u_ppwm_u_ex__0597_/Y
+ net444 VPWR VGND sg13g2_a22oi_1
XFILLER_30_299 VPWR VGND sg13g2_fill_2
Xu_ppwm_u_mem__0855_ net486 VPWR u_ppwm_u_mem__0855_/Y VGND net329 net395 sg13g2_o21ai_1
XFILLER_7_484 VPWR VGND sg13g2_decap_8
Xu_ppwm_u_ex__0643_ u_ppwm_u_ex__0642_/B u_ppwm_u_ex__0642_/A u_ppwm_u_ex__0642_/C
+ u_ppwm_u_ex__0648_/B VPWR VGND sg13g2_a21o_1
XFILLER_48_1010 VPWR VGND sg13g2_decap_8
Xu_ppwm_u_ex__0574_ VPWR u_ppwm_u_ex__0574_/Y net435 VGND sg13g2_inv_1
Xu_ppwm_u_mem__0786_ net460 VPWR u_ppwm_u_mem__0786_/Y VGND hold63/A net471 sg13g2_o21ai_1
XFILLER_39_801 VPWR VGND sg13g2_decap_8
XFILLER_39_878 VPWR VGND sg13g2_decap_8
Xu_ppwm_u_global_counter__115_ u_ppwm_u_global_counter__120_/D net426 net427 VPWR
+ VGND sg13g2_nand2_1
Xu_ppwm_u_ex__1126_ net50 VGND VPWR net689 hold305/A clknet_5_17__leaf_clk sg13g2_dfrbpq_1
XFILLER_0_1001 VPWR VGND sg13g2_decap_8
Xu_ppwm_u_ex__1057_ u_ppwm_u_ex__1056_/Y u_ppwm_u_ex__1055_/Y net354 u_ppwm_u_ex__1058_/C
+ VPWR VGND sg13g2_a21o_1
XFILLER_38_399 VPWR VGND sg13g2_fill_2
XFILLER_22_756 VPWR VGND sg13g2_decap_8
XFILLER_10_929 VPWR VGND sg13g2_decap_8
XFILLER_21_288 VPWR VGND sg13g2_decap_8
XFILLER_0_115 VPWR VGND sg13g2_decap_8
Xu_ppwm_u_pwm__248__198 VPWR VGND net198 sg13g2_tiehi
XFILLER_28_11 VPWR VGND sg13g2_decap_8
XFILLER_28_33 VPWR VGND sg13g2_fill_2
XFILLER_29_344 VPWR VGND sg13g2_decap_8
XFILLER_29_355 VPWR VGND sg13g2_fill_1
XFILLER_45_837 VPWR VGND sg13g2_decap_8
XFILLER_17_517 VPWR VGND sg13g2_decap_8
XFILLER_28_77 VPWR VGND sg13g2_fill_1
XFILLER_25_550 VPWR VGND sg13g2_decap_8
XFILLER_40_520 VPWR VGND sg13g2_decap_8
XFILLER_13_756 VPWR VGND sg13g2_decap_8
XFILLER_40_597 VPWR VGND sg13g2_decap_8
XFILLER_9_738 VPWR VGND sg13g2_decap_8
XFILLER_8_259 VPWR VGND sg13g2_fill_1
XFILLER_5_944 VPWR VGND sg13g2_decap_8
XFILLER_5_15 VPWR VGND sg13g2_decap_8
XFILLER_4_410 VPWR VGND sg13g2_decap_8
Xu_ppwm_u_mem__0640_ VPWR u_ppwm_u_mem__0640_/Y net318 VGND sg13g2_inv_1
XFILLER_4_487 VPWR VGND sg13g2_decap_8
XFILLER_48_653 VPWR VGND sg13g2_decap_8
XFILLER_0_693 VPWR VGND sg13g2_decap_8
XFILLER_36_837 VPWR VGND sg13g2_decap_8
Xu_ppwm_u_mem__1123_ net105 VGND VPWR net271 hold53/A clknet_5_26__leaf_clk sg13g2_dfrbpq_1
Xu_ppwm_u_mem__1054_ VGND VPWR u_ppwm_u_mem__0605_/Y net405 hold105/A u_ppwm_u_mem__1053_/Y
+ sg13g2_a21oi_1
XFILLER_16_583 VPWR VGND sg13g2_decap_8
XFILLER_31_586 VPWR VGND sg13g2_decap_8
Xu_ppwm_u_mem__0907_ net489 VPWR u_ppwm_u_mem__0907_/Y VGND hold125/A net401 sg13g2_o21ai_1
Xhold215 hold215/A VPWR VGND net598 sg13g2_dlygate4sd3_1
Xhold226 hold226/A VPWR VGND net609 sg13g2_dlygate4sd3_1
Xhold204 hold204/A VPWR VGND net587 sg13g2_dlygate4sd3_1
Xu_ppwm_u_mem__0838_ VGND VPWR u_ppwm_u_mem__0713_/Y net396 hold58/A u_ppwm_u_mem__0837_/Y
+ sg13g2_a21oi_1
Xhold237 hold237/A VPWR VGND net620 sg13g2_dlygate4sd3_1
Xhold259 hold259/A VPWR VGND net642 sg13g2_dlygate4sd3_1
Xhold248 hold248/A VPWR VGND net631 sg13g2_dlygate4sd3_1
Xu_ppwm_u_ex__0626_ u_ppwm/instr\[2\] u_ppwm_u_ex__0626_/C u_ppwm/instr\[0\] u_ppwm_u_ex__0652_/B
+ VPWR VGND sg13g2_nand3_1
Xu_ppwm_u_mem__0769_ hold44/A net466 u_ppwm_u_mem__0769_/Y VPWR VGND sg13g2_nor2b_1
XFILLER_39_675 VPWR VGND sg13g2_decap_8
Xu_ppwm_u_ex__1109_ net341 VPWR u_ppwm_u_ex__1110_/A VGND net351 u_ppwm_u_ex__1108_/Y
+ sg13g2_o21ai_1
XFILLER_27_848 VPWR VGND sg13g2_decap_8
XFILLER_42_818 VPWR VGND sg13g2_decap_8
XFILLER_35_870 VPWR VGND sg13g2_decap_8
XFILLER_22_553 VPWR VGND sg13g2_decap_8
XFILLER_10_726 VPWR VGND sg13g2_decap_8
XFILLER_6_708 VPWR VGND sg13g2_decap_8
XFILLER_2_914 VPWR VGND sg13g2_decap_8
XFILLER_1_468 VPWR VGND sg13g2_decap_8
XFILLER_49_439 VPWR VGND sg13g2_decap_8
XFILLER_39_54 VPWR VGND sg13g2_fill_2
XFILLER_45_634 VPWR VGND sg13g2_decap_8
XFILLER_44_122 VPWR VGND sg13g2_fill_2
XFILLER_18_837 VPWR VGND sg13g2_decap_8
XFILLER_29_196 VPWR VGND sg13g2_fill_1
XFILLER_44_199 VPWR VGND sg13g2_fill_2
XFILLER_32_328 VPWR VGND sg13g2_decap_4
XFILLER_13_553 VPWR VGND sg13g2_decap_8
XFILLER_41_895 VPWR VGND sg13g2_decap_8
XFILLER_9_535 VPWR VGND sg13g2_decap_8
XFILLER_40_394 VPWR VGND sg13g2_fill_1
XFILLER_40_383 VPWR VGND sg13g2_fill_2
XFILLER_5_741 VPWR VGND sg13g2_decap_8
Xu_ppwm_u_mem__0623_ VPWR u_ppwm_u_mem__0623_/Y net309 VGND sg13g2_inv_1
Xclkbuf_5_27__f_clk clknet_4_13_0_clk clknet_5_27__leaf_clk VPWR VGND sg13g2_buf_8
XFILLER_0_490 VPWR VGND sg13g2_decap_8
XFILLER_48_450 VPWR VGND sg13g2_decap_8
XFILLER_36_634 VPWR VGND sg13g2_decap_8
Xu_ppwm_u_mem__1106_ net138 VGND VPWR u_ppwm_u_mem__1106_/D hold86/A clknet_5_15__leaf_clk
+ sg13g2_dfrbpq_1
XFILLER_17_881 VPWR VGND sg13g2_decap_8
Xu_ppwm_u_mem__1037_ net498 VPWR u_ppwm_u_mem__1037_/Y VGND net280 net405 sg13g2_o21ai_1
XFILLER_16_391 VPWR VGND sg13g2_decap_4
XFILLER_32_851 VPWR VGND sg13g2_decap_8
XFILLER_31_350 VPWR VGND sg13g2_decap_8
Xu_ppwm_u_ex__0609_ net365 net368 u_ppwm_u_ex__0846_/A VPWR VGND sg13g2_nor2_2
Xfanout503 net505 net503 VPWR VGND sg13g2_buf_8
XFILLER_39_472 VPWR VGND sg13g2_decap_8
XFILLER_27_645 VPWR VGND sg13g2_decap_8
XFILLER_42_615 VPWR VGND sg13g2_decap_8
XFILLER_15_829 VPWR VGND sg13g2_decap_8
XFILLER_23_840 VPWR VGND sg13g2_decap_8
XFILLER_10_523 VPWR VGND sg13g2_decap_8
XFILLER_6_505 VPWR VGND sg13g2_decap_8
XFILLER_2_711 VPWR VGND sg13g2_decap_8
XFILLER_2_788 VPWR VGND sg13g2_decap_8
Xu_ppwm_u_mem__1118__115 VPWR VGND net115 sg13g2_tiehi
XFILLER_18_634 VPWR VGND sg13g2_decap_8
XFILLER_46_965 VPWR VGND sg13g2_decap_8
Xu_ppwm_u_ex__0960_ u_ppwm_u_ex__0960_/Y u_ppwm_u_ex__0960_/A u_ppwm_u_ex__0960_/B
+ VPWR VGND sg13g2_nand2_1
XFILLER_33_648 VPWR VGND sg13g2_decap_8
XFILLER_14_884 VPWR VGND sg13g2_decap_8
XFILLER_41_692 VPWR VGND sg13g2_decap_8
Xu_ppwm_u_ex__0891_ net350 VPWR u_ppwm_u_ex__0891_/Y VGND u_ppwm_u_ex__0886_/Y u_ppwm_u_ex__0889_/Y
+ sg13g2_o21ai_1
Xu_ppwm_u_mem__0606_ VPWR u_ppwm_u_mem__0606_/Y net261 VGND sg13g2_inv_1
XFILLER_37_910 VPWR VGND sg13g2_decap_8
XFILLER_37_987 VPWR VGND sg13g2_decap_8
XFILLER_23_169 VPWR VGND sg13g2_fill_2
XFILLER_20_832 VPWR VGND sg13g2_decap_8
XFILLER_31_180 VPWR VGND sg13g2_fill_2
XFILLER_11_69 VPWR VGND sg13g2_fill_1
Xfanout344 net346 net344 VPWR VGND sg13g2_buf_8
Xfanout355 fanout356/A net355 VPWR VGND sg13g2_buf_8
Xfanout366 net367 net366 VPWR VGND sg13g2_buf_8
Xfanout399 net402 net399 VPWR VGND sg13g2_buf_8
Xclkbuf_5_10__f_clk clknet_4_5_0_clk clknet_5_10__leaf_clk VPWR VGND sg13g2_buf_8
Xfanout388 net391 net388 VPWR VGND sg13g2_buf_1
Xfanout377 fanout377/A net377 VPWR VGND sg13g2_buf_8
XFILLER_28_910 VPWR VGND sg13g2_decap_8
XFILLER_27_442 VPWR VGND sg13g2_decap_8
XFILLER_15_626 VPWR VGND sg13g2_decap_8
XFILLER_28_987 VPWR VGND sg13g2_decap_8
XFILLER_43_946 VPWR VGND sg13g2_decap_8
XFILLER_42_489 VPWR VGND sg13g2_decap_8
XFILLER_11_843 VPWR VGND sg13g2_decap_8
XFILLER_10_331 VPWR VGND sg13g2_decap_4
Xu_ppwm_u_pwm__130_ VPWR u_ppwm_u_pwm__130_/Y net235 VGND sg13g2_inv_1
XFILLER_7_869 VPWR VGND sg13g2_decap_8
XFILLER_2_585 VPWR VGND sg13g2_decap_8
XFILLER_38_707 VPWR VGND sg13g2_decap_8
XFILLER_19_921 VPWR VGND sg13g2_decap_8
Xu_ppwm_u_ex__1090_ u_ppwm_u_ex__1090_/A u_ppwm_u_ex__1090_/B u_ppwm_u_ex__1090_/X
+ VPWR VGND sg13g2_and2_1
XFILLER_46_762 VPWR VGND sg13g2_decap_8
XFILLER_19_998 VPWR VGND sg13g2_decap_8
XFILLER_34_913 VPWR VGND sg13g2_decap_8
XFILLER_33_423 VPWR VGND sg13g2_fill_1
Xu_ppwm_u_ex__0943_ u_ppwm_u_ex__0943_/A u_ppwm_u_ex__0943_/B u_ppwm_u_ex__1128_/D
+ VPWR VGND sg13g2_nor2_1
XFILLER_14_681 VPWR VGND sg13g2_decap_8
Xu_ppwm_u_ex__0874_ u_ppwm_u_ex__0933_/B u_ppwm_u_ex__0874_/B u_ppwm_u_ex__0874_/C
+ u_ppwm_u_ex__0874_/D u_ppwm_u_ex__0874_/Y VPWR VGND sg13g2_nor4_1
XFILLER_47_0 VPWR VGND sg13g2_decap_8
XFILLER_25_935 VPWR VGND sg13g2_decap_8
XFILLER_37_784 VPWR VGND sg13g2_decap_8
XFILLER_40_905 VPWR VGND sg13g2_decap_8
XFILLER_12_618 VPWR VGND sg13g2_decap_8
XFILLER_24_467 VPWR VGND sg13g2_decap_8
XFILLER_11_139 VPWR VGND sg13g2_fill_1
XFILLER_47_548 VPWR VGND sg13g2_decap_8
XFILLER_47_76 VPWR VGND sg13g2_fill_1
XFILLER_28_784 VPWR VGND sg13g2_decap_8
XFILLER_43_743 VPWR VGND sg13g2_decap_8
XFILLER_16_968 VPWR VGND sg13g2_decap_8
Xu_ppwm_u_mem__0940_ VGND VPWR u_ppwm_u_mem__0662_/Y net414 u_ppwm_u_mem__1140_/D
+ u_ppwm_u_mem__0939_/Y sg13g2_a21oi_1
XFILLER_11_640 VPWR VGND sg13g2_decap_8
Xu_ppwm_u_mem__0871_ net491 VPWR u_ppwm_u_mem__0871_/Y VGND net278 net399 sg13g2_o21ai_1
XFILLER_7_666 VPWR VGND sg13g2_decap_8
XFILLER_12_90 VPWR VGND sg13g2_fill_2
Xu_ppwm_u_ex__0590_ net375 u_ppwm_u_ex__0896_/B VPWR VGND sg13g2_inv_4
XFILLER_40_7 VPWR VGND sg13g2_fill_1
XFILLER_3_861 VPWR VGND sg13g2_decap_8
XFILLER_2_360 VPWR VGND sg13g2_fill_1
XFILLER_38_504 VPWR VGND sg13g2_decap_8
Xu_ppwm_u_global_counter__131_ net618 u_ppwm_u_global_counter__131_/B u_ppwm_u_global_counter__169_/D
+ VPWR VGND sg13g2_nor2_1
Xu_ppwm_u_ex__1073_ u_ppwm_u_ex__1073_/A u_ppwm_u_ex__1073_/B u_ppwm_u_ex__1073_/C
+ u_ppwm_u_ex__1075_/A VPWR VGND sg13g2_nor3_1
XFILLER_34_710 VPWR VGND sg13g2_decap_8
XFILLER_19_795 VPWR VGND sg13g2_decap_8
XFILLER_34_787 VPWR VGND sg13g2_decap_8
XFILLER_15_990 VPWR VGND sg13g2_decap_8
XFILLER_22_938 VPWR VGND sg13g2_decap_8
Xu_ppwm_u_ex__0926_ net362 net442 u_ppwm_u_ex__0927_/A VPWR VGND sg13g2_xor2_1
Xu_ppwm_u_ex__0857_ VGND VPWR u_ppwm_u_ex__0854_/Y u_ppwm_u_ex__0888_/A u_ppwm_u_ex__0857_/Y
+ net349 sg13g2_a21oi_1
Xu_ppwm_u_ex__0788_ u_ppwm_u_ex__0789_/A u_ppwm_u_ex__0845_/C fanout350/A VPWR VGND
+ sg13g2_and2_1
XFILLER_17_68 VPWR VGND sg13g2_fill_1
XFILLER_25_732 VPWR VGND sg13g2_decap_8
XFILLER_37_581 VPWR VGND sg13g2_decap_8
XFILLER_40_702 VPWR VGND sg13g2_decap_8
XFILLER_13_938 VPWR VGND sg13g2_decap_8
XFILLER_40_779 VPWR VGND sg13g2_decap_8
XFILLER_24_297 VPWR VGND sg13g2_fill_1
XFILLER_21_960 VPWR VGND sg13g2_decap_8
XFILLER_32_1026 VPWR VGND sg13g2_fill_2
XFILLER_4_669 VPWR VGND sg13g2_decap_8
Xclkbuf_5_8__f_clk clknet_4_4_0_clk clknet_5_8__leaf_clk VPWR VGND sg13g2_buf_8
XFILLER_0_875 VPWR VGND sg13g2_decap_8
XFILLER_48_835 VPWR VGND sg13g2_decap_8
Xhold8 hold8/A VPWR VGND net225 sg13g2_dlygate4sd3_1
Xu_ppwm_u_mem__1070_ hold178/A net560 u_ppwm_u_mem__1075_/B VPWR VGND sg13g2_nand2_1
XFILLER_28_581 VPWR VGND sg13g2_decap_8
XFILLER_43_540 VPWR VGND sg13g2_decap_8
XFILLER_16_765 VPWR VGND sg13g2_decap_8
Xu_ppwm_u_mem__1089__172 VPWR VGND net172 sg13g2_tiehi
XFILLER_31_768 VPWR VGND sg13g2_decap_8
Xu_ppwm_u_mem__0923_ net505 VPWR u_ppwm_u_mem__0923_/Y VGND net266 net418 sg13g2_o21ai_1
XFILLER_8_920 VPWR VGND sg13g2_decap_8
XFILLER_12_982 VPWR VGND sg13g2_decap_8
Xu_ppwm_u_ex__0711_ VPWR VGND u_ppwm_u_ex__0709_/Y u_ppwm_u_ex__0710_/Y u_ppwm_u_ex__0708_/Y
+ net446 u_ppwm_u_ex__0711_/Y u_ppwm_u_ex__0599_/Y sg13g2_a221oi_1
Xu_ppwm_u_mem__0854_ VGND VPWR u_ppwm_u_mem__0705_/Y net394 u_ppwm_u_mem__1097_/D
+ u_ppwm_u_mem__0853_/Y sg13g2_a21oi_1
XFILLER_8_997 VPWR VGND sg13g2_decap_8
XFILLER_7_463 VPWR VGND sg13g2_decap_8
Xu_ppwm_u_ex__0642_ u_ppwm_u_ex__0642_/B u_ppwm_u_ex__0642_/C u_ppwm_u_ex__0642_/A
+ u_ppwm_u_ex__0644_/B VPWR VGND sg13g2_nand3_1
Xu_ppwm_u_ex__0573_ VPWR u_ppwm_u_ex__0573_/Y net434 VGND sg13g2_inv_1
Xu_ppwm_u_mem__0785_ hold104/A net471 u_ppwm_u_mem__0785_/Y VPWR VGND sg13g2_nor2b_1
XFILLER_39_857 VPWR VGND sg13g2_decap_8
Xu_ppwm_u_global_counter__114_ VGND VPWR net427 u_ppwm_u_global_counter__116_/C hold269/A
+ net426 sg13g2_a21oi_1
Xu_ppwm_u_ex__1125_ net52 VGND VPWR u_ppwm_u_ex__1125_/D hold278/A clknet_5_21__leaf_clk
+ sg13g2_dfrbpq_2
XFILLER_26_529 VPWR VGND sg13g2_decap_8
XFILLER_38_389 VPWR VGND sg13g2_decap_4
XFILLER_0_71 VPWR VGND sg13g2_fill_2
Xu_ppwm_u_ex__1056_ u_ppwm_u_ex__1056_/Y net347 hold266/A net359 hold294/A VPWR VGND
+ sg13g2_a22oi_1
XFILLER_19_592 VPWR VGND sg13g2_decap_8
Xu_ppwm_u_mem__1199_ net86 VGND VPWR net543 hold159/A clknet_5_18__leaf_clk sg13g2_dfrbpq_1
XFILLER_22_735 VPWR VGND sg13g2_decap_8
XFILLER_34_584 VPWR VGND sg13g2_decap_8
XFILLER_10_908 VPWR VGND sg13g2_decap_8
XFILLER_21_245 VPWR VGND sg13g2_fill_2
Xu_ppwm_u_ex__0909_ net364 net443 u_ppwm_u_ex__0929_/B VPWR VGND sg13g2_xor2_1
XFILLER_45_816 VPWR VGND sg13g2_decap_8
XFILLER_29_367 VPWR VGND sg13g2_fill_1
XFILLER_44_326 VPWR VGND sg13g2_fill_2
XFILLER_44_44 VPWR VGND sg13g2_fill_1
XFILLER_44_11 VPWR VGND sg13g2_fill_1
XFILLER_12_212 VPWR VGND sg13g2_fill_1
XFILLER_13_735 VPWR VGND sg13g2_decap_8
XFILLER_9_717 VPWR VGND sg13g2_decap_8
XFILLER_12_245 VPWR VGND sg13g2_fill_2
XFILLER_40_576 VPWR VGND sg13g2_decap_8
XFILLER_5_923 VPWR VGND sg13g2_decap_8
Xclkbuf_4_0_0_clk clknet_0_clk clknet_4_0_0_clk VPWR VGND sg13g2_buf_8
XFILLER_4_466 VPWR VGND sg13g2_decap_8
XFILLER_0_672 VPWR VGND sg13g2_decap_8
XFILLER_48_632 VPWR VGND sg13g2_decap_8
XFILLER_47_131 VPWR VGND sg13g2_fill_2
XFILLER_47_120 VPWR VGND sg13g2_decap_8
Xu_ppwm_u_mem__1122_ net107 VGND VPWR net228 hold10/A clknet_5_27__leaf_clk sg13g2_dfrbpq_1
XFILLER_36_816 VPWR VGND sg13g2_decap_8
Xu_ppwm_u_mem__1053_ net498 VPWR u_ppwm_u_mem__1053_/Y VGND hold180/A net407 sg13g2_o21ai_1
XFILLER_16_562 VPWR VGND sg13g2_decap_8
Xu_ppwm_u_mem__1167__100 VPWR VGND net100 sg13g2_tiehi
XFILLER_31_565 VPWR VGND sg13g2_decap_8
Xu_ppwm_u_mem__0906_ VGND VPWR u_ppwm_u_mem__0679_/Y net403 hold54/A u_ppwm_u_mem__0905_/Y
+ sg13g2_a21oi_1
Xu_ppwm_u_mem__0837_ net485 VPWR u_ppwm_u_mem__0837_/Y VGND hold59/A net394 sg13g2_o21ai_1
XFILLER_8_794 VPWR VGND sg13g2_decap_8
Xhold205 hold205/A VPWR VGND net588 sg13g2_dlygate4sd3_1
Xhold216 hold216/A VPWR VGND net599 sg13g2_dlygate4sd3_1
Xhold238 hold238/A VPWR VGND net621 sg13g2_dlygate4sd3_1
Xhold249 hold249/A VPWR VGND net632 sg13g2_dlygate4sd3_1
Xhold227 hold227/A VPWR VGND net610 sg13g2_dlygate4sd3_1
Xu_ppwm_u_ex__0625_ u_ppwm_u_ex__0626_/C u_ppwm_u_ex__0625_/A u_ppwm/instr\[1\] VPWR
+ VGND sg13g2_nand2_1
Xu_ppwm_u_mem__0768_ u_ppwm_u_mem__0767_/Y VPWR u_ppwm/instr\[2\] VGND u_ppwm_u_mem__0760_/Y
+ u_ppwm_u_mem__0761_/Y sg13g2_o21ai_1
Xu_ppwm_u_mem__0699_ VPWR u_ppwm_u_mem__0699_/Y net525 VGND sg13g2_inv_1
XFILLER_39_654 VPWR VGND sg13g2_decap_8
XFILLER_27_827 VPWR VGND sg13g2_decap_8
Xu_ppwm_u_ex__1108_ VPWR VGND net642 u_ppwm_u_ex__1107_/Y net347 hold234/A u_ppwm_u_ex__1108_/Y
+ net348 sg13g2_a221oi_1
XFILLER_38_175 VPWR VGND sg13g2_fill_2
Xu_ppwm_u_ex__1039_ VPWR u_ppwm_u_ex__1039_/Y u_ppwm_u_ex__1039_/A VGND sg13g2_inv_1
XFILLER_14_25 VPWR VGND sg13g2_decap_8
XFILLER_22_532 VPWR VGND sg13g2_decap_8
XFILLER_10_705 VPWR VGND sg13g2_decap_8
XFILLER_30_79 VPWR VGND sg13g2_fill_2
XFILLER_1_447 VPWR VGND sg13g2_decap_8
XFILLER_39_11 VPWR VGND sg13g2_fill_2
XFILLER_49_418 VPWR VGND sg13g2_decap_8
XFILLER_45_613 VPWR VGND sg13g2_decap_8
XFILLER_18_816 VPWR VGND sg13g2_decap_8
XFILLER_17_326 VPWR VGND sg13g2_fill_1
XFILLER_17_337 VPWR VGND sg13g2_fill_1
XFILLER_26_893 VPWR VGND sg13g2_decap_8
XFILLER_13_532 VPWR VGND sg13g2_decap_8
XFILLER_25_381 VPWR VGND sg13g2_fill_1
XFILLER_41_874 VPWR VGND sg13g2_decap_8
XFILLER_9_514 VPWR VGND sg13g2_decap_8
XFILLER_5_720 VPWR VGND sg13g2_decap_8
XFILLER_5_797 VPWR VGND sg13g2_decap_8
Xu_ppwm_u_mem__0622_ VPWR u_ppwm_u_mem__0622_/Y net545 VGND sg13g2_inv_1
XFILLER_49_985 VPWR VGND sg13g2_decap_8
XFILLER_36_613 VPWR VGND sg13g2_decap_8
Xu_ppwm_u_mem__1105_ net140 VGND VPWR u_ppwm_u_mem__1105_/D hold176/A clknet_5_14__leaf_clk
+ sg13g2_dfrbpq_1
XFILLER_17_860 VPWR VGND sg13g2_decap_8
Xu_ppwm_u_mem__1036_ VGND VPWR u_ppwm_u_mem__0614_/Y net412 hold154/A u_ppwm_u_mem__1035_/Y
+ sg13g2_a21oi_1
XFILLER_32_830 VPWR VGND sg13g2_decap_8
XFILLER_8_591 VPWR VGND sg13g2_decap_8
Xu_ppwm_u_ex__0608_ u_ppwm/instr\[0\] u_ppwm/instr\[1\] u_ppwm/instr\[2\] u_ppwm_u_ex__0778_/C
+ VPWR VGND sg13g2_nor3_1
Xfanout504 net505 net504 VPWR VGND sg13g2_buf_1
XFILLER_39_451 VPWR VGND sg13g2_decap_8
XFILLER_27_624 VPWR VGND sg13g2_decap_8
XFILLER_15_808 VPWR VGND sg13g2_decap_8
XFILLER_10_502 VPWR VGND sg13g2_decap_8
XFILLER_23_896 VPWR VGND sg13g2_decap_8
XFILLER_41_56 VPWR VGND sg13g2_fill_1
XFILLER_10_579 VPWR VGND sg13g2_decap_8
Xu_ppwm_u_mem__1189__90 VPWR VGND net90 sg13g2_tiehi
XFILLER_2_767 VPWR VGND sg13g2_decap_8
XFILLER_49_204 VPWR VGND sg13g2_decap_4
XFILLER_46_944 VPWR VGND sg13g2_decap_8
XFILLER_18_613 VPWR VGND sg13g2_decap_8
XFILLER_45_487 VPWR VGND sg13g2_decap_8
XFILLER_33_627 VPWR VGND sg13g2_decap_8
XFILLER_26_690 VPWR VGND sg13g2_decap_8
XFILLER_32_126 VPWR VGND sg13g2_decap_8
XFILLER_13_340 VPWR VGND sg13g2_fill_1
XFILLER_14_863 VPWR VGND sg13g2_decap_8
XFILLER_41_671 VPWR VGND sg13g2_decap_8
Xu_ppwm_u_ex__0890_ u_ppwm_u_ex__0888_/X u_ppwm_u_ex__0854_/Y u_ppwm_u_ex__0887_/Y
+ u_ppwm_u_ex__0890_/X VPWR VGND sg13g2_a21o_2
XFILLER_9_366 VPWR VGND sg13g2_fill_1
XFILLER_9_344 VPWR VGND sg13g2_decap_8
XFILLER_12_1024 VPWR VGND sg13g2_decap_4
XFILLER_5_594 VPWR VGND sg13g2_decap_8
Xu_ppwm_u_mem__0605_ VPWR u_ppwm_u_mem__0605_/Y net321 VGND sg13g2_inv_1
XFILLER_49_782 VPWR VGND sg13g2_decap_8
XFILLER_37_966 VPWR VGND sg13g2_decap_8
XFILLER_36_487 VPWR VGND sg13g2_decap_8
XFILLER_23_137 VPWR VGND sg13g2_fill_1
XFILLER_24_649 VPWR VGND sg13g2_decap_8
XFILLER_23_148 VPWR VGND sg13g2_decap_8
XFILLER_23_159 VPWR VGND sg13g2_fill_1
Xu_ppwm_u_mem__1019_ net504 VPWR u_ppwm_u_mem__1019_/Y VGND net296 net409 sg13g2_o21ai_1
XFILLER_20_811 VPWR VGND sg13g2_decap_8
XFILLER_20_888 VPWR VGND sg13g2_decap_8
Xfanout356 fanout356/A net356 VPWR VGND sg13g2_buf_8
Xfanout345 net346 net345 VPWR VGND sg13g2_buf_8
Xfanout378 net379 net378 VPWR VGND sg13g2_buf_8
Xfanout367 fanout367/A net367 VPWR VGND sg13g2_buf_8
Xfanout389 net390 net389 VPWR VGND sg13g2_buf_8
XFILLER_28_966 VPWR VGND sg13g2_decap_8
XFILLER_43_925 VPWR VGND sg13g2_decap_8
XFILLER_15_605 VPWR VGND sg13g2_decap_8
XFILLER_27_498 VPWR VGND sg13g2_decap_8
XFILLER_42_468 VPWR VGND sg13g2_decap_8
XFILLER_30_619 VPWR VGND sg13g2_decap_8
XFILLER_10_310 VPWR VGND sg13g2_fill_1
XFILLER_11_822 VPWR VGND sg13g2_decap_8
XFILLER_23_693 VPWR VGND sg13g2_decap_8
XFILLER_35_1024 VPWR VGND sg13g2_decap_4
XFILLER_10_343 VPWR VGND sg13g2_fill_1
XFILLER_7_848 VPWR VGND sg13g2_decap_8
XFILLER_11_899 VPWR VGND sg13g2_decap_8
XFILLER_2_564 VPWR VGND sg13g2_decap_8
XFILLER_42_1028 VPWR VGND sg13g2_fill_1
XFILLER_19_900 VPWR VGND sg13g2_decap_8
XFILLER_46_741 VPWR VGND sg13g2_decap_8
XFILLER_19_977 VPWR VGND sg13g2_decap_8
XFILLER_45_240 VPWR VGND sg13g2_decap_8
XFILLER_18_487 VPWR VGND sg13g2_decap_8
XFILLER_33_413 VPWR VGND sg13g2_fill_1
XFILLER_34_969 VPWR VGND sg13g2_decap_8
Xu_ppwm_u_ex__0942_ net478 VPWR u_ppwm_u_ex__0943_/B VGND net442 net344 sg13g2_o21ai_1
XFILLER_14_660 VPWR VGND sg13g2_decap_8
XFILLER_20_118 VPWR VGND sg13g2_decap_8
XFILLER_9_141 VPWR VGND sg13g2_fill_2
Xu_ppwm_u_ex__0873_ u_ppwm_u_ex__0873_/A u_ppwm_u_ex__0933_/A u_ppwm_u_ex__0874_/D
+ VPWR VGND sg13g2_nor2_1
Xu_ppwm_u_pwm__189_ VGND VPWR u_ppwm_u_pwm__133_/Y net379 hold157/A u_ppwm_u_pwm__188_/Y
+ sg13g2_a21oi_1
Xu_ppwm_u_mem__1099__152 VPWR VGND net152 sg13g2_tiehi
XFILLER_3_1022 VPWR VGND sg13g2_decap_8
XFILLER_25_914 VPWR VGND sg13g2_decap_8
XFILLER_37_763 VPWR VGND sg13g2_decap_8
XFILLER_19_1019 VPWR VGND sg13g2_decap_8
XFILLER_24_446 VPWR VGND sg13g2_decap_8
XFILLER_11_129 VPWR VGND sg13g2_fill_2
XFILLER_33_991 VPWR VGND sg13g2_decap_8
XFILLER_20_685 VPWR VGND sg13g2_decap_8
XFILLER_0_7 VPWR VGND sg13g2_decap_8
XFILLER_47_11 VPWR VGND sg13g2_fill_2
XFILLER_47_527 VPWR VGND sg13g2_decap_8
XFILLER_47_33 VPWR VGND sg13g2_fill_2
XFILLER_19_207 VPWR VGND sg13g2_decap_4
XFILLER_28_763 VPWR VGND sg13g2_decap_8
XFILLER_43_722 VPWR VGND sg13g2_decap_8
XFILLER_16_947 VPWR VGND sg13g2_decap_8
XFILLER_15_457 VPWR VGND sg13g2_fill_2
XFILLER_43_799 VPWR VGND sg13g2_decap_8
XFILLER_30_405 VPWR VGND sg13g2_fill_1
XFILLER_42_298 VPWR VGND sg13g2_decap_4
XFILLER_23_490 VPWR VGND sg13g2_decap_8
Xu_ppwm_u_mem__0870_ VGND VPWR u_ppwm_u_mem__0697_/Y net399 u_ppwm_u_mem__1105_/D
+ u_ppwm_u_mem__0869_/Y sg13g2_a21oi_1
XFILLER_7_645 VPWR VGND sg13g2_decap_8
XFILLER_11_696 VPWR VGND sg13g2_decap_8
XFILLER_3_840 VPWR VGND sg13g2_decap_8
XFILLER_2_350 VPWR VGND sg13g2_fill_1
XFILLER_33_7 VPWR VGND sg13g2_decap_8
Xu_ppwm_u_global_counter__130_ u_ppwm_u_global_counter__131_/B net494 u_ppwm_u_global_counter__130_/B
+ VPWR VGND sg13g2_nand2_1
Xu_ppwm_u_ex__1141_ net38 VGND VPWR u_ppwm_u_ex__1141_/D hold293/A clknet_5_16__leaf_clk
+ sg13g2_dfrbpq_2
Xu_ppwm_u_ex__1072_ net341 VPWR u_ppwm_u_ex__1073_/C VGND net351 u_ppwm_u_ex__1071_/Y
+ sg13g2_o21ai_1
XFILLER_19_774 VPWR VGND sg13g2_decap_8
XFILLER_22_917 VPWR VGND sg13g2_decap_8
XFILLER_34_766 VPWR VGND sg13g2_decap_8
Xu_ppwm_u_ex__0925_ u_ppwm_u_ex__0925_/A u_ppwm_u_ex__0925_/B u_ppwm_u_ex__0925_/Y
+ VPWR VGND sg13g2_nor2_1
XFILLER_30_983 VPWR VGND sg13g2_decap_8
Xu_ppwm_u_ex__0856_ net366 net446 u_ppwm_u_ex__0888_/A VPWR VGND sg13g2_xor2_1
Xu_ppwm_u_ex__0787_ u_ppwm/instr\[2\] u_ppwm/instr\[1\] u_ppwm_u_ex__0845_/C VPWR
+ VGND sg13g2_nor2b_2
Xu_ppwm_u_mem__0999_ net488 VPWR u_ppwm_u_mem__0999_/Y VGND hold127/A net390 sg13g2_o21ai_1
XFILLER_25_1012 VPWR VGND sg13g2_decap_8
Xu_ppwm_u_mem__1177__179 VPWR VGND net179 sg13g2_tiehi
XFILLER_29_549 VPWR VGND sg13g2_decap_8
XFILLER_37_560 VPWR VGND sg13g2_decap_8
XFILLER_25_711 VPWR VGND sg13g2_decap_8
XFILLER_13_917 VPWR VGND sg13g2_decap_8
XFILLER_25_788 VPWR VGND sg13g2_decap_8
XFILLER_40_758 VPWR VGND sg13g2_decap_8
XFILLER_20_460 VPWR VGND sg13g2_fill_2
XFILLER_32_1005 VPWR VGND sg13g2_decap_8
XFILLER_20_482 VPWR VGND sg13g2_decap_8
XFILLER_4_648 VPWR VGND sg13g2_decap_8
XFILLER_0_854 VPWR VGND sg13g2_decap_8
XFILLER_48_814 VPWR VGND sg13g2_decap_8
Xhold9 hold9/A VPWR VGND net226 sg13g2_dlygate4sd3_1
XFILLER_28_560 VPWR VGND sg13g2_decap_8
XFILLER_15_210 VPWR VGND sg13g2_decap_8
XFILLER_16_744 VPWR VGND sg13g2_decap_8
XFILLER_43_596 VPWR VGND sg13g2_decap_8
XFILLER_15_265 VPWR VGND sg13g2_fill_2
XFILLER_31_747 VPWR VGND sg13g2_decap_8
Xu_ppwm_u_mem__0922_ VGND VPWR u_ppwm_u_mem__0671_/Y net419 u_ppwm_u_mem__1131_/D
+ u_ppwm_u_mem__0921_/Y sg13g2_a21oi_1
Xu_ppwm_u_ex__0710_ hold296/A net448 u_ppwm_u_ex__0710_/Y VPWR VGND sg13g2_nor2b_1
XFILLER_12_961 VPWR VGND sg13g2_decap_8
XFILLER_11_493 VPWR VGND sg13g2_decap_8
Xu_ppwm_u_mem__0853_ net485 VPWR u_ppwm_u_mem__0853_/Y VGND net523 net394 sg13g2_o21ai_1
XFILLER_8_976 VPWR VGND sg13g2_decap_8
Xu_ppwm_u_ex__0641_ u_ppwm_u_ex__0642_/C net455 net371 VPWR VGND sg13g2_xnor2_1
Xu_ppwm_u_ex__0572_ u_ppwm_u_ex__0769_/A hold275/A VPWR VGND sg13g2_inv_2
Xu_ppwm_u_mem__0784_ u_ppwm_u_mem__0783_/Y VPWR fanout377/A VGND u_ppwm_u_mem__0776_/Y
+ u_ppwm_u_mem__0777_/Y sg13g2_o21ai_1
XFILLER_39_836 VPWR VGND sg13g2_decap_8
Xu_ppwm_u_global_counter__113_ fanout429/A net663 u_ppwm_u_global_counter__164_/D
+ VPWR VGND sg13g2_nor2_1
Xu_ppwm_u_ex__1124_ net54 VGND VPWR u_ppwm_u_ex__1124_/D hold287/A clknet_5_21__leaf_clk
+ sg13g2_dfrbpq_1
XFILLER_26_508 VPWR VGND sg13g2_decap_8
XFILLER_47_891 VPWR VGND sg13g2_decap_8
Xu_ppwm_u_ex__1055_ u_ppwm_u_ex__1055_/Y net426 net348 VPWR VGND sg13g2_nand2_1
XFILLER_19_571 VPWR VGND sg13g2_decap_8
XFILLER_0_94 VPWR VGND sg13g2_decap_8
Xu_ppwm_u_mem__1198_ net102 VGND VPWR u_ppwm_u_mem__1198_/D hold180/A clknet_5_18__leaf_clk
+ sg13g2_dfrbpq_1
XFILLER_22_714 VPWR VGND sg13g2_decap_8
XFILLER_34_563 VPWR VGND sg13g2_decap_8
Xu_ppwm_u_ex__0908_ u_ppwm_u_ex__0885_/Y VPWR u_ppwm_u_ex__0908_/Y VGND u_ppwm_u_ex__0886_/Y
+ u_ppwm_u_ex__0889_/Y sg13g2_o21ai_1
XFILLER_30_780 VPWR VGND sg13g2_decap_8
Xu_ppwm_u_ex__0839_ net449 net346 u_ppwm_u_ex__0841_/A VPWR VGND sg13g2_nor2_1
XFILLER_1_629 VPWR VGND sg13g2_decap_8
XFILLER_13_714 VPWR VGND sg13g2_decap_8
XFILLER_25_585 VPWR VGND sg13g2_decap_8
XFILLER_40_555 VPWR VGND sg13g2_decap_8
XFILLER_8_239 VPWR VGND sg13g2_fill_2
XFILLER_5_902 VPWR VGND sg13g2_decap_8
XFILLER_5_979 VPWR VGND sg13g2_decap_8
XFILLER_4_445 VPWR VGND sg13g2_decap_8
XFILLER_48_611 VPWR VGND sg13g2_decap_8
XFILLER_0_651 VPWR VGND sg13g2_decap_8
XFILLER_48_688 VPWR VGND sg13g2_decap_8
XFILLER_47_154 VPWR VGND sg13g2_decap_8
Xu_ppwm_u_mem__1121_ net109 VGND VPWR u_ppwm_u_mem__1121_/D hold17/A clknet_5_27__leaf_clk
+ sg13g2_dfrbpq_1
XFILLER_47_198 VPWR VGND sg13g2_fill_1
XFILLER_16_541 VPWR VGND sg13g2_decap_8
XFILLER_18_90 VPWR VGND sg13g2_fill_1
Xu_ppwm_u_mem__1052_ VGND VPWR u_ppwm_u_mem__0606_/Y net405 hold45/A u_ppwm_u_mem__1051_/Y
+ sg13g2_a21oi_1
XFILLER_44_894 VPWR VGND sg13g2_decap_8
XFILLER_43_393 VPWR VGND sg13g2_decap_8
XFILLER_31_544 VPWR VGND sg13g2_decap_8
XFILLER_15_1011 VPWR VGND sg13g2_decap_8
Xu_ppwm_u_mem__0905_ net500 VPWR u_ppwm_u_mem__0905_/Y VGND hold72/A net401 sg13g2_o21ai_1
XFILLER_8_773 VPWR VGND sg13g2_decap_8
XFILLER_7_250 VPWR VGND sg13g2_decap_8
Xu_ppwm_u_mem__0836_ VGND VPWR u_ppwm_u_mem__0714_/Y net397 hold5/A u_ppwm_u_mem__0835_/Y
+ sg13g2_a21oi_1
Xhold206 hold206/A VPWR VGND net589 sg13g2_dlygate4sd3_1
Xhold217 hold217/A VPWR VGND net600 sg13g2_dlygate4sd3_1
Xu_ppwm_u_ex__0624_ u_ppwm_u_ex__0624_/B net603 net496 hold221/A VPWR VGND sg13g2_nand3_1
Xhold239 hold239/A VPWR VGND net622 sg13g2_dlygate4sd3_1
Xhold228 hold228/A VPWR VGND net611 sg13g2_dlygate4sd3_1
Xu_ppwm_u_mem__0767_ u_ppwm_u_mem__0767_/Y u_ppwm_u_mem__0831_/A u_ppwm_u_mem__0767_/B
+ VPWR VGND sg13g2_nand2_1
Xu_ppwm_u_mem__0698_ VPWR u_ppwm_u_mem__0698_/Y net549 VGND sg13g2_inv_1
XFILLER_39_633 VPWR VGND sg13g2_decap_8
XFILLER_22_1015 VPWR VGND sg13g2_decap_8
XFILLER_27_806 VPWR VGND sg13g2_decap_8
Xu_ppwm_u_ex__1107_ VGND VPWR net374 net360 u_ppwm_u_ex__1107_/Y u_ppwm_u_ex__0719_/A
+ sg13g2_a21oi_1
Xu_ppwm_u_mem__1126__99 VPWR VGND net99 sg13g2_tiehi
Xu_ppwm_u_ex__1038_ net366 VPWR u_ppwm_u_ex__1039_/A VGND hold244/A net439 sg13g2_o21ai_1
XFILLER_22_511 VPWR VGND sg13g2_decap_8
XFILLER_22_588 VPWR VGND sg13g2_decap_8
XFILLER_2_949 VPWR VGND sg13g2_decap_8
XFILLER_1_426 VPWR VGND sg13g2_decap_8
XFILLER_7_1009 VPWR VGND sg13g2_decap_8
XFILLER_29_176 VPWR VGND sg13g2_fill_2
XFILLER_45_669 VPWR VGND sg13g2_decap_8
XFILLER_33_809 VPWR VGND sg13g2_decap_8
XFILLER_26_872 VPWR VGND sg13g2_decap_8
XFILLER_38_1022 VPWR VGND sg13g2_decap_8
XFILLER_41_853 VPWR VGND sg13g2_decap_8
XFILLER_13_511 VPWR VGND sg13g2_decap_8
XFILLER_13_588 VPWR VGND sg13g2_decap_8
XFILLER_4_220 VPWR VGND sg13g2_fill_1
XFILLER_5_776 VPWR VGND sg13g2_decap_8
Xu_ppwm_u_mem__0621_ VPWR u_ppwm_u_mem__0621_/Y net296 VGND sg13g2_inv_1
XFILLER_45_1026 VPWR VGND sg13g2_fill_2
XFILLER_1_993 VPWR VGND sg13g2_decap_8
XFILLER_49_964 VPWR VGND sg13g2_decap_8
XFILLER_48_485 VPWR VGND sg13g2_decap_8
Xu_ppwm_u_mem__1104_ net142 VGND VPWR net550 hold166/A clknet_5_13__leaf_clk sg13g2_dfrbpq_1
XFILLER_35_135 VPWR VGND sg13g2_fill_2
XFILLER_36_669 VPWR VGND sg13g2_decap_8
Xu_ppwm_u_mem__1035_ net499 VPWR u_ppwm_u_mem__1035_/Y VGND hold163/A net412 sg13g2_o21ai_1
XFILLER_44_691 VPWR VGND sg13g2_decap_8
XFILLER_32_886 VPWR VGND sg13g2_decap_8
XFILLER_31_396 VPWR VGND sg13g2_fill_1
XFILLER_8_570 VPWR VGND sg13g2_decap_8
XFILLER_6_82 VPWR VGND sg13g2_decap_4
Xu_ppwm_u_ex__0607_ u_ppwm/instr\[0\] u_ppwm/instr\[1\] u_ppwm_u_ex__0812_/B VPWR
+ VGND sg13g2_nor2_1
Xu_ppwm_u_mem__0819_ u_ppwm_u_mem__0819_/Y hold41/A net469 VPWR VGND sg13g2_nand2_1
Xfanout505 net506 net505 VPWR VGND sg13g2_buf_8
XFILLER_39_430 VPWR VGND sg13g2_decap_4
XFILLER_27_603 VPWR VGND sg13g2_decap_8
XFILLER_41_127 VPWR VGND sg13g2_fill_2
XFILLER_22_341 VPWR VGND sg13g2_fill_2
XFILLER_23_875 VPWR VGND sg13g2_decap_8
XFILLER_41_24 VPWR VGND sg13g2_fill_2
XFILLER_10_558 VPWR VGND sg13g2_decap_8
XFILLER_2_746 VPWR VGND sg13g2_decap_8
XFILLER_2_18 VPWR VGND sg13g2_decap_8
XFILLER_46_923 VPWR VGND sg13g2_decap_8
XFILLER_18_669 VPWR VGND sg13g2_decap_8
XFILLER_45_466 VPWR VGND sg13g2_decap_8
XFILLER_33_606 VPWR VGND sg13g2_decap_8
XFILLER_14_842 VPWR VGND sg13g2_decap_8
XFILLER_41_650 VPWR VGND sg13g2_decap_8
XFILLER_15_80 VPWR VGND sg13g2_fill_2
XFILLER_12_1003 VPWR VGND sg13g2_decap_8
XFILLER_5_573 VPWR VGND sg13g2_decap_8
Xu_ppwm_u_mem__0604_ VPWR u_ppwm_u_mem__0604_/Y net563 VGND sg13g2_inv_1
XFILLER_1_790 VPWR VGND sg13g2_decap_8
XFILLER_49_761 VPWR VGND sg13g2_decap_8
XFILLER_37_945 VPWR VGND sg13g2_decap_8
XFILLER_24_628 VPWR VGND sg13g2_decap_8
XFILLER_36_455 VPWR VGND sg13g2_fill_2
XFILLER_16_190 VPWR VGND sg13g2_fill_1
Xu_ppwm_u_mem__1018_ VGND VPWR u_ppwm_u_mem__0623_/Y net408 hold93/A u_ppwm_u_mem__1017_/Y
+ sg13g2_a21oi_1
XFILLER_32_683 VPWR VGND sg13g2_decap_8
XFILLER_20_867 VPWR VGND sg13g2_decap_8
XFILLER_31_182 VPWR VGND sg13g2_fill_1
Xu_ppwm_u_global_counter__164__58 VPWR VGND net58 sg13g2_tiehi
Xfanout357 fanout358/A net357 VPWR VGND sg13g2_buf_8
Xfanout346 fanout346/A net346 VPWR VGND sg13g2_buf_8
XFILLER_47_709 VPWR VGND sg13g2_decap_8
Xfanout379 net380 net379 VPWR VGND sg13g2_buf_8
Xfanout368 net369 net368 VPWR VGND sg13g2_buf_8
XFILLER_27_400 VPWR VGND sg13g2_decap_4
XFILLER_28_945 VPWR VGND sg13g2_decap_8
XFILLER_43_904 VPWR VGND sg13g2_decap_8
XFILLER_27_477 VPWR VGND sg13g2_decap_8
XFILLER_42_436 VPWR VGND sg13g2_fill_2
XFILLER_35_1003 VPWR VGND sg13g2_decap_8
XFILLER_11_801 VPWR VGND sg13g2_decap_8
XFILLER_23_672 VPWR VGND sg13g2_decap_8
XFILLER_22_182 VPWR VGND sg13g2_fill_2
XFILLER_10_355 VPWR VGND sg13g2_fill_2
XFILLER_7_827 VPWR VGND sg13g2_decap_8
XFILLER_11_878 VPWR VGND sg13g2_decap_8
XFILLER_10_399 VPWR VGND sg13g2_fill_1
XFILLER_2_543 VPWR VGND sg13g2_decap_8
XFILLER_42_1007 VPWR VGND sg13g2_decap_8
XFILLER_37_208 VPWR VGND sg13g2_decap_8
XFILLER_46_720 VPWR VGND sg13g2_decap_8
XFILLER_19_956 VPWR VGND sg13g2_decap_8
XFILLER_46_797 VPWR VGND sg13g2_decap_8
XFILLER_34_948 VPWR VGND sg13g2_decap_8
Xu_ppwm_u_ex__0941_ u_ppwm_u_ex__0941_/A u_ppwm_u_ex__1073_/A u_ppwm_u_ex__0941_/C
+ u_ppwm_u_ex__0943_/A VPWR VGND sg13g2_nor3_1
XFILLER_33_469 VPWR VGND sg13g2_fill_2
XFILLER_13_171 VPWR VGND sg13g2_decap_8
Xu_ppwm_u_ex__0872_ u_ppwm_u_ex__0872_/A u_ppwm_u_ex__0872_/B u_ppwm_u_ex__0874_/C
+ VPWR VGND sg13g2_nor2_1
Xu_ppwm_u_pwm__188_ net478 VPWR u_ppwm_u_pwm__188_/Y VGND net445 net378 sg13g2_o21ai_1
XFILLER_3_1001 VPWR VGND sg13g2_decap_8
XFILLER_37_742 VPWR VGND sg13g2_decap_8
Xu_ppwm_u_pwm__253__214 VPWR VGND net214 sg13g2_tiehi
XFILLER_33_970 VPWR VGND sg13g2_decap_8
XFILLER_32_480 VPWR VGND sg13g2_decap_8
XFILLER_20_664 VPWR VGND sg13g2_decap_8
Xu_ppwm_u_mem__1147__176 VPWR VGND net176 sg13g2_tiehi
XFILLER_47_506 VPWR VGND sg13g2_decap_8
XFILLER_28_742 VPWR VGND sg13g2_decap_8
XFILLER_43_701 VPWR VGND sg13g2_decap_8
XFILLER_16_926 VPWR VGND sg13g2_decap_8
XFILLER_27_252 VPWR VGND sg13g2_fill_2
XFILLER_15_414 VPWR VGND sg13g2_decap_8
XFILLER_43_778 VPWR VGND sg13g2_decap_8
XFILLER_24_992 VPWR VGND sg13g2_decap_8
XFILLER_31_929 VPWR VGND sg13g2_decap_8
XFILLER_7_624 VPWR VGND sg13g2_decap_8
XFILLER_6_101 VPWR VGND sg13g2_fill_2
XFILLER_11_675 VPWR VGND sg13g2_decap_8
XFILLER_3_896 VPWR VGND sg13g2_decap_8
Xu_ppwm_u_ex__1140_ net30 VGND VPWR u_ppwm_u_ex__1140_/D hold298/A clknet_5_7__leaf_clk
+ sg13g2_dfrbpq_2
Xu_ppwm_u_ex__1071_ VPWR VGND hold256/A u_ppwm_u_ex__1070_/Y net347 hold291/A u_ppwm_u_ex__1071_/Y
+ net348 sg13g2_a221oi_1
XFILLER_38_539 VPWR VGND sg13g2_decap_8
XFILLER_19_753 VPWR VGND sg13g2_decap_8
XFILLER_46_594 VPWR VGND sg13g2_decap_8
XFILLER_34_745 VPWR VGND sg13g2_decap_8
XFILLER_33_255 VPWR VGND sg13g2_fill_2
Xu_ppwm_u_ex__0924_ u_ppwm_u_ex__0924_/A u_ppwm_u_ex__0922_/Y u_ppwm_u_ex__1127_/D
+ VPWR VGND sg13g2_nor2b_1
Xu_ppwm_u_ex__0855_ u_ppwm_u_ex__0855_/A u_ppwm_u_ex__0925_/B u_ppwm_u_ex__0855_/Y
+ VPWR VGND sg13g2_nor2_1
XFILLER_30_962 VPWR VGND sg13g2_decap_8
Xu_ppwm_u_ex__0786_ u_ppwm_u_ex__0786_/Y net356 net608 net358 net428 VPWR VGND sg13g2_a22oi_1
Xu_ppwm_u_mem__0998_ VGND VPWR u_ppwm_u_mem__0633_/Y net393 u_ppwm_u_mem__1169_/D
+ u_ppwm_u_mem__0997_/Y sg13g2_a21oi_1
XFILLER_29_528 VPWR VGND sg13g2_decap_8
XFILLER_44_509 VPWR VGND sg13g2_decap_8
XFILLER_25_767 VPWR VGND sg13g2_decap_8
XFILLER_40_737 VPWR VGND sg13g2_decap_8
XFILLER_33_14 VPWR VGND sg13g2_decap_8
XFILLER_12_439 VPWR VGND sg13g2_fill_2
Xu_ppwm_u_mem__1184__129 VPWR VGND net129 sg13g2_tiehi
XFILLER_32_1028 VPWR VGND sg13g2_fill_1
XFILLER_21_995 VPWR VGND sg13g2_decap_8
XFILLER_4_627 VPWR VGND sg13g2_decap_8
XFILLER_3_115 VPWR VGND sg13g2_fill_1
XFILLER_0_833 VPWR VGND sg13g2_decap_8
XFILLER_47_347 VPWR VGND sg13g2_decap_4
XFILLER_16_723 VPWR VGND sg13g2_decap_8
XFILLER_43_575 VPWR VGND sg13g2_decap_8
XFILLER_31_726 VPWR VGND sg13g2_decap_8
XFILLER_12_940 VPWR VGND sg13g2_decap_8
XFILLER_15_299 VPWR VGND sg13g2_fill_2
Xu_ppwm_u_mem__0921_ net505 VPWR u_ppwm_u_mem__0921_/Y VGND net295 net418 sg13g2_o21ai_1
XFILLER_11_450 VPWR VGND sg13g2_fill_1
XFILLER_8_955 VPWR VGND sg13g2_decap_8
XFILLER_7_421 VPWR VGND sg13g2_fill_1
Xu_ppwm_u_mem__0852_ VGND VPWR u_ppwm_u_mem__0706_/Y net395 hold23/A u_ppwm_u_mem__0851_/Y
+ sg13g2_a21oi_1
Xu_ppwm_u_ex__0640_ u_ppwm_u_ex__0648_/A net455 net371 VPWR VGND sg13g2_nand2_1
XFILLER_7_498 VPWR VGND sg13g2_decap_8
Xu_ppwm_u_ex__0571_ VPWR u_ppwm_u_ex__0571_/Y net431 VGND sg13g2_inv_1
Xu_ppwm_u_mem__0783_ u_ppwm_u_mem__0783_/Y u_ppwm_u_mem__0831_/A u_ppwm_u_mem__0783_/B
+ VPWR VGND sg13g2_nand2_1
XFILLER_48_1024 VPWR VGND sg13g2_decap_4
XFILLER_3_693 VPWR VGND sg13g2_decap_8
Xu_ppwm_u_pwm__243__213 VPWR VGND net213 sg13g2_tiehi
XFILLER_39_815 VPWR VGND sg13g2_decap_8
XFILLER_24_4 VPWR VGND sg13g2_fill_2
Xu_ppwm_u_global_counter__112_ hold280/A net427 u_ppwm_u_global_counter__116_/C VPWR
+ VGND sg13g2_xnor2_1
Xu_ppwm_u_ex__1123_ net27 VGND VPWR u_ppwm_u_ex__1123_/D hold301/A clknet_5_21__leaf_clk
+ sg13g2_dfrbpq_2
XFILLER_19_550 VPWR VGND sg13g2_decap_8
Xu_ppwm_u_ex__1054_ fanout349/A u_ppwm_u_ex__1054_/B u_ppwm_u_ex__1054_/Y VPWR VGND
+ sg13g2_nor2_1
XFILLER_47_870 VPWR VGND sg13g2_decap_8
XFILLER_0_1015 VPWR VGND sg13g2_decap_8
XFILLER_0_73 VPWR VGND sg13g2_fill_1
XFILLER_34_542 VPWR VGND sg13g2_decap_8
Xu_ppwm_u_mem__1197_ net118 VGND VPWR net322 hold104/A clknet_5_25__leaf_clk sg13g2_dfrbpq_1
XFILLER_21_247 VPWR VGND sg13g2_fill_1
Xu_ppwm_u_ex__0907_ u_ppwm_u_ex__0907_/A u_ppwm_u_ex__0905_/Y hold306/A VPWR VGND
+ sg13g2_nor2b_1
Xu_ppwm_u_ex__0838_ u_ppwm_u_ex__1009_/A u_ppwm_u_ex__0838_/C net345 u_ppwm_u_ex__0838_/Y
+ VPWR VGND u_ppwm_u_ex__0838_/D sg13g2_nand4_1
Xu_ppwm_u_ex__0769_ u_ppwm_u_ex__0769_/A net425 u_ppwm_u_ex__0771_/B VPWR VGND sg13g2_nor2_1
XFILLER_1_608 VPWR VGND sg13g2_decap_8
XFILLER_0_129 VPWR VGND sg13g2_decap_8
XFILLER_44_328 VPWR VGND sg13g2_fill_1
XFILLER_25_564 VPWR VGND sg13g2_decap_8
XFILLER_40_534 VPWR VGND sg13g2_decap_8
XFILLER_12_247 VPWR VGND sg13g2_fill_1
XFILLER_12_258 VPWR VGND sg13g2_fill_1
XFILLER_21_792 VPWR VGND sg13g2_decap_8
Xclkbuf_5_16__f_clk clknet_4_8_0_clk clknet_5_16__leaf_clk VPWR VGND sg13g2_buf_8
XFILLER_5_958 VPWR VGND sg13g2_decap_8
XFILLER_4_424 VPWR VGND sg13g2_decap_8
XFILLER_0_630 VPWR VGND sg13g2_decap_8
XFILLER_48_667 VPWR VGND sg13g2_decap_8
Xu_ppwm_u_mem__1120_ net111 VGND VPWR u_ppwm_u_mem__1120_/D hold56/A clknet_5_26__leaf_clk
+ sg13g2_dfrbpq_1
XFILLER_29_892 VPWR VGND sg13g2_decap_8
XFILLER_35_306 VPWR VGND sg13g2_fill_1
XFILLER_16_520 VPWR VGND sg13g2_decap_8
Xu_ppwm_u_mem__1051_ net498 VPWR u_ppwm_u_mem__1051_/Y VGND hold104/A net405 sg13g2_o21ai_1
XFILLER_35_339 VPWR VGND sg13g2_fill_2
XFILLER_44_873 VPWR VGND sg13g2_decap_8
XFILLER_16_597 VPWR VGND sg13g2_decap_8
XFILLER_31_523 VPWR VGND sg13g2_decap_8
Xu_ppwm_u_mem__0904_ VGND VPWR u_ppwm_u_mem__0680_/Y net411 hold11/A u_ppwm_u_mem__0903_/Y
+ sg13g2_a21oi_1
XFILLER_8_752 VPWR VGND sg13g2_decap_8
Xu_ppwm_u_mem__0835_ net485 VPWR u_ppwm_u_mem__0835_/Y VGND hold57/A net396 sg13g2_o21ai_1
Xu_ppwm_u_ex__0623_ hold220/A u_ppwm_u_ex__0623_/A net602 VPWR VGND sg13g2_nand2_1
Xhold207 hold207/A VPWR VGND net590 sg13g2_dlygate4sd3_1
Xhold229 hold229/A VPWR VGND net612 sg13g2_dlygate4sd3_1
Xhold218 hold218/A VPWR VGND net601 sg13g2_dlygate4sd3_1
Xu_ppwm_u_mem__0766_ net457 u_ppwm_u_mem__0765_/X u_ppwm_u_mem__0764_/X u_ppwm_u_mem__0762_/X
+ u_ppwm_u_mem__0763_/X net456 u_ppwm_u_mem__0767_/B VPWR VGND sg13g2_mux4_1
Xu_ppwm_u_mem__0697_ VPWR u_ppwm_u_mem__0697_/Y net559 VGND sg13g2_inv_1
XFILLER_4_991 VPWR VGND sg13g2_decap_8
XFILLER_3_490 VPWR VGND sg13g2_decap_8
XFILLER_39_612 VPWR VGND sg13g2_decap_8
Xu_ppwm_u_ex__1106_ u_ppwm_u_ex__1105_/Y VPWR u_ppwm_u_ex__1106_/Y VGND u_ppwm_u_ex__1103_/Y
+ u_ppwm_u_ex__1104_/Y sg13g2_o21ai_1
XFILLER_38_122 VPWR VGND sg13g2_fill_1
XFILLER_39_689 VPWR VGND sg13g2_decap_8
XFILLER_19_391 VPWR VGND sg13g2_fill_1
Xu_ppwm_u_ex__1037_ u_ppwm_u_ex__1065_/A net435 net365 VPWR VGND sg13g2_xnor2_1
XFILLER_35_884 VPWR VGND sg13g2_decap_8
XFILLER_22_567 VPWR VGND sg13g2_decap_8
XFILLER_30_15 VPWR VGND sg13g2_decap_8
XFILLER_2_928 VPWR VGND sg13g2_decap_8
XFILLER_1_405 VPWR VGND sg13g2_decap_8
XFILLER_45_648 VPWR VGND sg13g2_decap_8
XFILLER_26_851 VPWR VGND sg13g2_decap_8
XFILLER_38_1001 VPWR VGND sg13g2_decap_8
XFILLER_41_832 VPWR VGND sg13g2_decap_8
XFILLER_13_567 VPWR VGND sg13g2_decap_8
XFILLER_9_549 VPWR VGND sg13g2_decap_8
XFILLER_5_755 VPWR VGND sg13g2_decap_8
Xu_ppwm_u_mem__0620_ VPWR u_ppwm_u_mem__0620_/Y net331 VGND sg13g2_inv_1
XFILLER_4_276 VPWR VGND sg13g2_fill_2
XFILLER_45_1005 VPWR VGND sg13g2_decap_8
XFILLER_1_972 VPWR VGND sg13g2_decap_8
XFILLER_49_943 VPWR VGND sg13g2_decap_8
XFILLER_48_464 VPWR VGND sg13g2_decap_8
Xhold90 hold90/A VPWR VGND net307 sg13g2_dlygate4sd3_1
Xu_ppwm_u_mem__1103_ net144 VGND VPWR net526 hold142/A clknet_5_13__leaf_clk sg13g2_dfrbpq_1
XFILLER_36_648 VPWR VGND sg13g2_decap_8
Xu_ppwm_u_mem__1034_ VGND VPWR u_ppwm_u_mem__0615_/Y net406 hold68/A u_ppwm_u_mem__1033_/Y
+ sg13g2_a21oi_1
XFILLER_44_670 VPWR VGND sg13g2_decap_8
XFILLER_16_383 VPWR VGND sg13g2_fill_2
XFILLER_17_895 VPWR VGND sg13g2_decap_8
XFILLER_31_320 VPWR VGND sg13g2_fill_2
XFILLER_32_865 VPWR VGND sg13g2_decap_8
XFILLER_31_386 VPWR VGND sg13g2_fill_1
Xu_ppwm_u_ex__0606_ u_ppwm_u_ex__0606_/Y hold216/A VPWR VGND sg13g2_inv_2
Xu_ppwm_u_mem__0818_ net460 VPWR u_ppwm_u_mem__0818_/Y VGND hold126/A net466 sg13g2_o21ai_1
Xu_ppwm_u_mem__0749_ hold152/A hold72/A net463 u_ppwm_u_mem__0749_/X VPWR VGND sg13g2_mux2_1
Xfanout506 rst_n net506 VPWR VGND sg13g2_buf_8
XFILLER_39_486 VPWR VGND sg13g2_decap_8
XFILLER_27_659 VPWR VGND sg13g2_decap_8
XFILLER_42_629 VPWR VGND sg13g2_decap_8
XFILLER_35_681 VPWR VGND sg13g2_decap_8
XFILLER_23_854 VPWR VGND sg13g2_decap_8
XFILLER_10_537 VPWR VGND sg13g2_decap_8
XFILLER_6_519 VPWR VGND sg13g2_decap_8
XFILLER_2_725 VPWR VGND sg13g2_decap_8
XFILLER_46_902 VPWR VGND sg13g2_decap_8
XFILLER_18_648 VPWR VGND sg13g2_decap_8
XFILLER_46_979 VPWR VGND sg13g2_decap_8
XFILLER_14_821 VPWR VGND sg13g2_decap_8
XFILLER_13_331 VPWR VGND sg13g2_decap_8
XFILLER_40_161 VPWR VGND sg13g2_fill_2
XFILLER_14_898 VPWR VGND sg13g2_decap_8
XFILLER_9_379 VPWR VGND sg13g2_fill_2
Xu_ppwm_u_mem__1205__157 VPWR VGND net157 sg13g2_tiehi
XFILLER_5_552 VPWR VGND sg13g2_decap_8
Xu_ppwm_u_mem__0603_ VPWR u_ppwm_u_mem__0603_/Y net542 VGND sg13g2_inv_1
XFILLER_49_740 VPWR VGND sg13g2_decap_8
XFILLER_37_924 VPWR VGND sg13g2_decap_8
XFILLER_24_607 VPWR VGND sg13g2_decap_8
XFILLER_17_692 VPWR VGND sg13g2_decap_8
XFILLER_16_180 VPWR VGND sg13g2_fill_1
Xu_ppwm_u_mem__1017_ net504 VPWR u_ppwm_u_mem__1017_/Y VGND hold162/A net408 sg13g2_o21ai_1
XFILLER_32_662 VPWR VGND sg13g2_decap_8
XFILLER_20_846 VPWR VGND sg13g2_decap_8
XFILLER_28_1022 VPWR VGND sg13g2_decap_8
Xfanout347 fanout347/A net347 VPWR VGND sg13g2_buf_8
Xfanout358 fanout358/A net358 VPWR VGND sg13g2_buf_1
Xfanout369 net371 net369 VPWR VGND sg13g2_buf_8
XFILLER_28_924 VPWR VGND sg13g2_decap_8
XFILLER_36_14 VPWR VGND sg13g2_decap_8
XFILLER_27_456 VPWR VGND sg13g2_decap_8
XFILLER_23_651 VPWR VGND sg13g2_decap_8
XFILLER_7_806 VPWR VGND sg13g2_decap_8
XFILLER_11_857 VPWR VGND sg13g2_decap_8
XFILLER_10_378 VPWR VGND sg13g2_fill_2
XFILLER_2_522 VPWR VGND sg13g2_decap_8
XFILLER_2_599 VPWR VGND sg13g2_decap_8
XFILLER_18_434 VPWR VGND sg13g2_fill_1
XFILLER_19_935 VPWR VGND sg13g2_decap_8
XFILLER_46_776 VPWR VGND sg13g2_decap_8
XFILLER_34_927 VPWR VGND sg13g2_decap_8
Xu_ppwm_u_ex__0940_ net344 VPWR u_ppwm_u_ex__0941_/C VGND net351 u_ppwm_u_ex__0939_/Y
+ sg13g2_o21ai_1
XFILLER_33_459 VPWR VGND sg13g2_fill_2
XFILLER_42_993 VPWR VGND sg13g2_decap_8
Xu_ppwm_u_ex__0871_ u_ppwm_u_ex__0870_/Y VPWR u_ppwm_u_ex__0882_/B VGND u_ppwm_u_ex__0867_/Y
+ u_ppwm_u_ex__0869_/Y sg13g2_o21ai_1
XFILLER_14_695 VPWR VGND sg13g2_decap_8
XFILLER_42_90 VPWR VGND sg13g2_fill_2
Xu_ppwm_u_pwm__187_ VGND VPWR u_ppwm_u_pwm__134_/Y net379 hold196/A u_ppwm_u_pwm__186_/Y
+ sg13g2_a21oi_1
XFILLER_6_883 VPWR VGND sg13g2_decap_8
XFILLER_28_209 VPWR VGND sg13g2_fill_2
XFILLER_36_220 VPWR VGND sg13g2_decap_8
XFILLER_37_721 VPWR VGND sg13g2_decap_8
XFILLER_25_949 VPWR VGND sg13g2_decap_8
XFILLER_37_798 VPWR VGND sg13g2_decap_8
XFILLER_40_919 VPWR VGND sg13g2_decap_8
XFILLER_20_643 VPWR VGND sg13g2_decap_8
XFILLER_22_16 VPWR VGND sg13g2_decap_8
XFILLER_32_470 VPWR VGND sg13g2_fill_1
XFILLER_4_809 VPWR VGND sg13g2_decap_8
XFILLER_28_721 VPWR VGND sg13g2_decap_8
XFILLER_16_905 VPWR VGND sg13g2_decap_8
XFILLER_28_798 VPWR VGND sg13g2_decap_8
XFILLER_43_757 VPWR VGND sg13g2_decap_8
XFILLER_31_908 VPWR VGND sg13g2_decap_8
XFILLER_24_971 VPWR VGND sg13g2_decap_8
XFILLER_10_120 VPWR VGND sg13g2_fill_1
XFILLER_7_603 VPWR VGND sg13g2_decap_8
XFILLER_11_654 VPWR VGND sg13g2_decap_8
XFILLER_10_164 VPWR VGND sg13g2_fill_2
XFILLER_3_875 VPWR VGND sg13g2_decap_8
XFILLER_2_396 VPWR VGND sg13g2_decap_8
XFILLER_38_518 VPWR VGND sg13g2_decap_8
Xu_ppwm_u_ex__1070_ VGND VPWR net374 net360 u_ppwm_u_ex__1070_/Y u_ppwm_u_ex__0925_/A
+ sg13g2_a21oi_1
XFILLER_19_732 VPWR VGND sg13g2_decap_8
XFILLER_18_231 VPWR VGND sg13g2_decap_4
XFILLER_46_573 VPWR VGND sg13g2_decap_8
XFILLER_34_724 VPWR VGND sg13g2_decap_8
XFILLER_33_245 VPWR VGND sg13g2_fill_1
XFILLER_42_790 VPWR VGND sg13g2_decap_8
Xu_ppwm_u_ex__0923_ net478 VPWR u_ppwm_u_ex__0924_/A VGND net443 net344 sg13g2_o21ai_1
XFILLER_14_492 VPWR VGND sg13g2_decap_8
XFILLER_30_941 VPWR VGND sg13g2_decap_8
XFILLER_33_289 VPWR VGND sg13g2_fill_2
Xu_ppwm_u_ex__0854_ u_ppwm_u_ex__0833_/Y VPWR u_ppwm_u_ex__0854_/Y VGND u_ppwm_u_ex__0790_/Y
+ u_ppwm_u_ex__0834_/Y sg13g2_o21ai_1
Xu_ppwm_u_pwm__239_ net199 VGND VPWR net585 hold200/A clknet_5_0__leaf_clk sg13g2_dfrbpq_2
Xu_ppwm_u_ex__0785_ net357 net355 net352 u_ppwm_u_ex__0785_/Y VPWR VGND sg13g2_nor3_2
Xu_ppwm_u_mem__0997_ net487 VPWR u_ppwm_u_mem__0997_/Y VGND net268 net393 sg13g2_o21ai_1
XFILLER_6_680 VPWR VGND sg13g2_decap_8
XFILLER_45_0 VPWR VGND sg13g2_decap_8
XFILLER_29_507 VPWR VGND sg13g2_decap_8
XFILLER_24_245 VPWR VGND sg13g2_fill_1
XFILLER_25_746 VPWR VGND sg13g2_decap_8
XFILLER_37_595 VPWR VGND sg13g2_decap_8
XFILLER_40_716 VPWR VGND sg13g2_decap_8
XFILLER_21_974 VPWR VGND sg13g2_decap_8
XFILLER_4_606 VPWR VGND sg13g2_decap_8
XFILLER_0_812 VPWR VGND sg13g2_decap_8
XFILLER_47_304 VPWR VGND sg13g2_fill_2
XFILLER_0_889 VPWR VGND sg13g2_decap_8
XFILLER_48_849 VPWR VGND sg13g2_decap_8
XFILLER_16_702 VPWR VGND sg13g2_decap_8
XFILLER_28_595 VPWR VGND sg13g2_decap_8
XFILLER_43_554 VPWR VGND sg13g2_decap_8
XFILLER_15_278 VPWR VGND sg13g2_decap_8
XFILLER_16_779 VPWR VGND sg13g2_decap_8
XFILLER_31_705 VPWR VGND sg13g2_decap_8
XFILLER_30_226 VPWR VGND sg13g2_decap_8
Xu_ppwm_u_mem__0920_ VGND VPWR u_ppwm_u_mem__0672_/Y net418 u_ppwm_u_mem__1130_/D
+ u_ppwm_u_mem__0919_/Y sg13g2_a21oi_1
Xu_ppwm_u_mem__0851_ net485 VPWR u_ppwm_u_mem__0851_/Y VGND hold155/A net394 sg13g2_o21ai_1
XFILLER_8_934 VPWR VGND sg13g2_decap_8
XFILLER_12_996 VPWR VGND sg13g2_decap_8
Xu_ppwm_u_mem__0782_ net462 u_ppwm_u_mem__0781_/X u_ppwm_u_mem__0780_/X u_ppwm_u_mem__0778_/X
+ u_ppwm_u_mem__0779_/X net456 u_ppwm_u_mem__0783_/B VPWR VGND sg13g2_mux4_1
XFILLER_7_477 VPWR VGND sg13g2_decap_8
XFILLER_48_1003 VPWR VGND sg13g2_decap_8
XFILLER_3_672 VPWR VGND sg13g2_decap_8
XFILLER_2_182 VPWR VGND sg13g2_decap_8
Xu_ppwm_u_ex__1122_ net31 VGND VPWR u_ppwm_u_ex__1122_/D hold277/A clknet_5_20__leaf_clk
+ sg13g2_dfrbpq_1
Xu_ppwm_u_global_counter__111_ u_ppwm_u_global_counter__116_/C net672 hold290/A VPWR
+ VGND sg13g2_nor2b_1
XFILLER_17_4 VPWR VGND sg13g2_decap_8
Xu_ppwm_u_ex__1053_ VGND VPWR u_ppwm_u_ex__1052_/A u_ppwm_u_ex__1052_/B u_ppwm_u_ex__1054_/B
+ u_ppwm_u_ex__1065_/B sg13g2_a21oi_1
XFILLER_34_521 VPWR VGND sg13g2_decap_8
Xu_ppwm_u_mem__1196_ net133 VGND VPWR net262 hold44/A clknet_5_25__leaf_clk sg13g2_dfrbpq_1
XFILLER_22_749 VPWR VGND sg13g2_decap_8
XFILLER_34_598 VPWR VGND sg13g2_decap_8
Xu_ppwm_u_ex__0906_ net494 VPWR u_ppwm_u_ex__0907_/A VGND net444 net345 sg13g2_o21ai_1
XFILLER_9_83 VPWR VGND sg13g2_fill_1
Xu_ppwm_u_ex__0837_ VGND VPWR net440 u_ppwm_u_ex__0785_/Y u_ppwm_u_ex__0838_/D u_ppwm_u_ex__0832_/Y
+ sg13g2_a21oi_1
Xu_ppwm_u_ex__0768_ net424 net431 u_ppwm_u_ex__0771_/A VPWR VGND sg13g2_nor2b_1
XFILLER_0_108 VPWR VGND sg13g2_decap_8
Xu_ppwm_u_ex__0699_ u_ppwm_u_ex__0699_/A u_ppwm_u_ex__0699_/B u_ppwm_u_ex__0699_/Y
+ VPWR VGND sg13g2_nor2_1
XFILLER_28_26 VPWR VGND sg13g2_decap_8
XFILLER_38_882 VPWR VGND sg13g2_decap_8
XFILLER_25_543 VPWR VGND sg13g2_decap_8
XFILLER_44_58 VPWR VGND sg13g2_fill_2
XFILLER_40_513 VPWR VGND sg13g2_decap_8
XFILLER_13_749 VPWR VGND sg13g2_decap_8
XFILLER_21_771 VPWR VGND sg13g2_decap_8
XFILLER_5_937 VPWR VGND sg13g2_decap_8
XFILLER_4_403 VPWR VGND sg13g2_decap_8
XFILLER_0_686 VPWR VGND sg13g2_decap_8
XFILLER_48_646 VPWR VGND sg13g2_decap_8
XFILLER_29_871 VPWR VGND sg13g2_decap_8
Xu_ppwm_u_mem__1050_ VGND VPWR u_ppwm_u_mem__0607_/Y net406 hold31/A u_ppwm_u_mem__1049_/Y
+ sg13g2_a21oi_1
XFILLER_44_852 VPWR VGND sg13g2_decap_8
XFILLER_16_576 VPWR VGND sg13g2_decap_8
XFILLER_31_502 VPWR VGND sg13g2_decap_8
XFILLER_34_80 VPWR VGND sg13g2_fill_2
XFILLER_8_731 VPWR VGND sg13g2_decap_8
XFILLER_31_579 VPWR VGND sg13g2_decap_8
Xu_ppwm_u_mem__0903_ net500 VPWR u_ppwm_u_mem__0903_/Y VGND hold53/A net411 sg13g2_o21ai_1
XFILLER_11_270 VPWR VGND sg13g2_decap_8
XFILLER_11_281 VPWR VGND sg13g2_fill_1
XFILLER_12_793 VPWR VGND sg13g2_decap_8
Xu_ppwm_u_mem__0834_ hold3/A hold227/A fanout421/A VPWR VGND u_ppwm_u_mem__1212_/Q
+ sg13g2_nand3b_1
Xu_ppwm_u_ex__0622_ u_ppwm_u_ex__0995_/A u_ppwm_u_ex__0622_/B u_ppwm_u_ex__0652_/A
+ u_ppwm_u_ex__0624_/B VPWR VGND sg13g2_or3_1
Xhold208 hold208/A VPWR VGND net591 sg13g2_dlygate4sd3_1
Xu_ppwm_u_mem__0765_ hold59/A hold155/A net464 u_ppwm_u_mem__0765_/X VPWR VGND sg13g2_mux2_1
Xhold219 hold219/A VPWR VGND net602 sg13g2_dlygate4sd3_1
Xu_ppwm_u_mem__1104__142 VPWR VGND net142 sg13g2_tiehi
XFILLER_4_970 VPWR VGND sg13g2_decap_8
Xu_ppwm_u_mem__0696_ VPWR u_ppwm_u_mem__0696_/Y net303 VGND sg13g2_inv_1
XFILLER_39_668 VPWR VGND sg13g2_decap_8
Xu_ppwm_u_ex__1105_ VGND VPWR u_ppwm_u_ex__1103_/Y u_ppwm_u_ex__1104_/Y u_ppwm_u_ex__1105_/Y
+ net349 sg13g2_a21oi_1
XFILLER_26_307 VPWR VGND sg13g2_fill_2
Xu_ppwm_u_ex__1036_ u_ppwm_u_ex__1052_/A net435 net365 VPWR VGND sg13g2_nand2_1
XFILLER_19_370 VPWR VGND sg13g2_decap_4
Xclkbuf_5_22__f_clk clknet_4_11_0_clk clknet_5_22__leaf_clk VPWR VGND sg13g2_buf_8
Xu_ppwm_u_mem__1179_ net169 VGND VPWR net310 hold92/A clknet_5_22__leaf_clk sg13g2_dfrbpq_1
XFILLER_35_863 VPWR VGND sg13g2_decap_8
XFILLER_14_39 VPWR VGND sg13g2_decap_4
XFILLER_22_546 VPWR VGND sg13g2_decap_8
XFILLER_10_719 VPWR VGND sg13g2_decap_8
XFILLER_2_907 VPWR VGND sg13g2_decap_8
XFILLER_45_627 VPWR VGND sg13g2_decap_8
XFILLER_26_830 VPWR VGND sg13g2_decap_8
XFILLER_41_811 VPWR VGND sg13g2_decap_8
XFILLER_13_546 VPWR VGND sg13g2_decap_8
XFILLER_25_395 VPWR VGND sg13g2_decap_4
XFILLER_41_888 VPWR VGND sg13g2_decap_8
XFILLER_9_528 VPWR VGND sg13g2_decap_8
XFILLER_4_200 VPWR VGND sg13g2_decap_4
XFILLER_5_734 VPWR VGND sg13g2_decap_8
Xu_ppwm_u_mem__1197__118 VPWR VGND net118 sg13g2_tiehi
XFILLER_20_71 VPWR VGND sg13g2_fill_1
XFILLER_45_1028 VPWR VGND sg13g2_fill_1
XFILLER_1_951 VPWR VGND sg13g2_decap_8
XFILLER_49_922 VPWR VGND sg13g2_decap_8
XFILLER_48_443 VPWR VGND sg13g2_decap_8
XFILLER_0_483 VPWR VGND sg13g2_decap_8
XFILLER_49_999 VPWR VGND sg13g2_decap_8
Xhold91 hold91/A VPWR VGND net308 sg13g2_dlygate4sd3_1
Xhold80 hold80/A VPWR VGND net297 sg13g2_dlygate4sd3_1
XFILLER_36_627 VPWR VGND sg13g2_decap_8
Xu_ppwm_u_mem__1102_ net146 VGND VPWR net516 hold132/A clknet_5_13__leaf_clk sg13g2_dfrbpq_1
XFILLER_17_874 VPWR VGND sg13g2_decap_8
Xu_ppwm_u_mem__1033_ net499 VPWR u_ppwm_u_mem__1033_/Y VGND hold153/A net406 sg13g2_o21ai_1
XFILLER_16_395 VPWR VGND sg13g2_fill_2
XFILLER_31_343 VPWR VGND sg13g2_decap_8
XFILLER_32_844 VPWR VGND sg13g2_decap_8
XFILLER_12_590 VPWR VGND sg13g2_decap_8
Xu_ppwm_u_ex__0605_ VPWR u_ppwm_u_ex__0751_/B hold272/A VGND sg13g2_inv_1
Xu_ppwm_u_mem__0817_ hold159/A net465 u_ppwm_u_mem__0817_/Y VPWR VGND sg13g2_nor2b_1
Xu_ppwm_u_mem__0748_ hold97/A hold66/A net473 u_ppwm_u_mem__0748_/X VPWR VGND sg13g2_mux2_1
Xu_ppwm_u_mem__0679_ VPWR u_ppwm_u_mem__0679_/Y net270 VGND sg13g2_inv_1
XFILLER_39_465 VPWR VGND sg13g2_decap_8
XFILLER_27_638 VPWR VGND sg13g2_decap_8
XFILLER_42_608 VPWR VGND sg13g2_decap_8
Xu_ppwm_u_ex__1019_ u_ppwm_u_ex__1023_/B u_ppwm_u_ex__1019_/A net342 VPWR VGND sg13g2_nand2_1
XFILLER_35_660 VPWR VGND sg13g2_decap_8
XFILLER_41_129 VPWR VGND sg13g2_fill_1
XFILLER_23_833 VPWR VGND sg13g2_decap_8
XFILLER_10_516 VPWR VGND sg13g2_decap_8
XFILLER_41_26 VPWR VGND sg13g2_fill_1
XFILLER_2_704 VPWR VGND sg13g2_decap_8
XFILLER_18_627 VPWR VGND sg13g2_decap_8
XFILLER_46_958 VPWR VGND sg13g2_decap_8
XFILLER_14_800 VPWR VGND sg13g2_decap_8
XFILLER_41_685 VPWR VGND sg13g2_decap_8
XFILLER_14_877 VPWR VGND sg13g2_decap_8
XFILLER_9_358 VPWR VGND sg13g2_fill_1
XFILLER_5_531 VPWR VGND sg13g2_decap_8
XFILLER_49_7 VPWR VGND sg13g2_decap_8
Xu_ppwm_u_mem__0602_ VPWR u_ppwm_u_mem__0602_/Y net626 VGND sg13g2_inv_1
XFILLER_37_903 VPWR VGND sg13g2_decap_8
XFILLER_49_796 VPWR VGND sg13g2_decap_8
XFILLER_48_273 VPWR VGND sg13g2_decap_4
XFILLER_45_991 VPWR VGND sg13g2_decap_8
XFILLER_17_671 VPWR VGND sg13g2_decap_8
Xu_ppwm_u_mem__1016_ VGND VPWR u_ppwm_u_mem__0624_/Y net408 u_ppwm_u_mem__1178_/D
+ u_ppwm_u_mem__1015_/Y sg13g2_a21oi_1
XFILLER_32_641 VPWR VGND sg13g2_decap_8
XFILLER_20_825 VPWR VGND sg13g2_decap_8
XFILLER_31_173 VPWR VGND sg13g2_decap_8
XFILLER_9_892 VPWR VGND sg13g2_decap_8
XFILLER_28_1001 VPWR VGND sg13g2_decap_8
Xfanout348 fanout348/A net348 VPWR VGND sg13g2_buf_8
Xfanout359 fanout359/A net359 VPWR VGND sg13g2_buf_8
XFILLER_28_903 VPWR VGND sg13g2_decap_8
XFILLER_39_284 VPWR VGND sg13g2_fill_2
XFILLER_39_273 VPWR VGND sg13g2_fill_1
XFILLER_27_435 VPWR VGND sg13g2_decap_8
XFILLER_43_939 VPWR VGND sg13g2_decap_8
XFILLER_42_427 VPWR VGND sg13g2_fill_1
XFILLER_42_405 VPWR VGND sg13g2_decap_4
XFILLER_15_619 VPWR VGND sg13g2_decap_8
XFILLER_36_991 VPWR VGND sg13g2_decap_8
Xu_ppwm_u_mem__1187__106 VPWR VGND net106 sg13g2_tiehi
XFILLER_42_438 VPWR VGND sg13g2_fill_1
XFILLER_23_630 VPWR VGND sg13g2_decap_8
XFILLER_10_324 VPWR VGND sg13g2_decap_8
XFILLER_11_836 VPWR VGND sg13g2_decap_8
XFILLER_22_184 VPWR VGND sg13g2_fill_1
Xu_ppwm_u_global_counter__163__60 VPWR VGND net60 sg13g2_tiehi
XFILLER_2_501 VPWR VGND sg13g2_decap_8
XFILLER_2_578 VPWR VGND sg13g2_decap_8
XFILLER_19_914 VPWR VGND sg13g2_decap_8
XFILLER_46_755 VPWR VGND sg13g2_decap_8
XFILLER_18_457 VPWR VGND sg13g2_fill_2
XFILLER_34_906 VPWR VGND sg13g2_decap_8
XFILLER_42_972 VPWR VGND sg13g2_decap_8
XFILLER_14_674 VPWR VGND sg13g2_decap_8
XFILLER_41_482 VPWR VGND sg13g2_decap_8
Xu_ppwm_u_ex__0870_ VGND VPWR u_ppwm_u_ex__0867_/Y u_ppwm_u_ex__0869_/Y u_ppwm_u_ex__0870_/Y
+ net349 sg13g2_a21oi_1
XFILLER_10_880 VPWR VGND sg13g2_decap_8
Xu_ppwm_u_pwm__255_ net210 VGND VPWR net226 net3 clknet_5_7__leaf_clk sg13g2_dfrbpq_1
XFILLER_6_862 VPWR VGND sg13g2_decap_8
Xu_ppwm_u_pwm__186_ net478 VPWR u_ppwm_u_pwm__186_/Y VGND hold278/A net378 sg13g2_o21ai_1
Xu_ppwm_u_mem__1168__96 VPWR VGND net96 sg13g2_tiehi
XFILLER_37_700 VPWR VGND sg13g2_decap_8
XFILLER_49_593 VPWR VGND sg13g2_decap_8
XFILLER_37_777 VPWR VGND sg13g2_decap_8
XFILLER_18_991 VPWR VGND sg13g2_decap_8
XFILLER_25_928 VPWR VGND sg13g2_decap_8
XFILLER_32_460 VPWR VGND sg13g2_decap_4
XFILLER_20_622 VPWR VGND sg13g2_decap_8
Xu_ppwm_u_ex__0999_ u_ppwm_u_ex__0999_/A net342 u_ppwm_u_ex__0999_/Y VPWR VGND sg13g2_nor2b_1
XFILLER_20_699 VPWR VGND sg13g2_decap_8
XFILLER_28_700 VPWR VGND sg13g2_decap_8
XFILLER_28_777 VPWR VGND sg13g2_decap_8
XFILLER_43_736 VPWR VGND sg13g2_decap_8
XFILLER_24_950 VPWR VGND sg13g2_decap_8
XFILLER_11_633 VPWR VGND sg13g2_decap_8
XFILLER_7_659 VPWR VGND sg13g2_decap_8
XFILLER_3_854 VPWR VGND sg13g2_decap_8
XFILLER_19_711 VPWR VGND sg13g2_decap_8
XFILLER_46_552 VPWR VGND sg13g2_decap_8
Xclkbuf_5_3__f_clk clknet_4_1_0_clk clknet_5_3__leaf_clk VPWR VGND sg13g2_buf_8
XFILLER_19_788 VPWR VGND sg13g2_decap_8
XFILLER_34_703 VPWR VGND sg13g2_decap_8
XFILLER_33_257 VPWR VGND sg13g2_fill_1
Xu_ppwm_u_ex__0922_ u_ppwm_u_ex__0922_/B u_ppwm_u_ex__1058_/A net346 u_ppwm_u_ex__0922_/Y
+ VPWR VGND u_ppwm_u_ex__0922_/D sg13g2_nand4_1
XFILLER_14_471 VPWR VGND sg13g2_decap_8
XFILLER_15_983 VPWR VGND sg13g2_decap_8
XFILLER_30_920 VPWR VGND sg13g2_decap_8
Xu_ppwm_u_ex__0853_ VPWR VGND u_ppwm_u_ex__0803_/A u_ppwm_u_ex__0850_/Y u_ppwm_u_ex__0966_/B
+ u_ppwm_u_ex__0803_/B u_ppwm_u_ex__0863_/B u_ppwm_u_ex__0804_/Y sg13g2_a221oi_1
XFILLER_30_997 VPWR VGND sg13g2_decap_8
Xu_ppwm_u_pwm__238_ net201 VGND VPWR net634 hold250/A clknet_5_0__leaf_clk sg13g2_dfrbpq_2
Xu_ppwm_u_ex__0784_ net357 net355 u_ppwm_u_ex__0970_/B VPWR VGND sg13g2_nor2_1
Xu_ppwm_u_mem__0996_ VGND VPWR u_ppwm_u_mem__0634_/Y net385 hold33/A u_ppwm_u_mem__0995_/Y
+ sg13g2_a21oi_1
Xu_ppwm_u_pwm__169_ u_ppwm_u_pwm__175_/A u_ppwm_u_pwm__169_/B u_ppwm_u_pwm__242_/D
+ VPWR VGND sg13g2_nor2_1
XFILLER_38_0 VPWR VGND sg13g2_decap_8
XFILLER_25_1026 VPWR VGND sg13g2_fill_2
XFILLER_49_390 VPWR VGND sg13g2_decap_8
XFILLER_25_725 VPWR VGND sg13g2_decap_8
XFILLER_37_574 VPWR VGND sg13g2_decap_8
XFILLER_24_224 VPWR VGND sg13g2_decap_4
XFILLER_12_408 VPWR VGND sg13g2_decap_4
XFILLER_12_419 VPWR VGND sg13g2_fill_1
XFILLER_21_953 VPWR VGND sg13g2_decap_8
XFILLER_32_1019 VPWR VGND sg13g2_decap_8
XFILLER_20_496 VPWR VGND sg13g2_decap_8
XFILLER_48_828 VPWR VGND sg13g2_decap_8
XFILLER_0_868 VPWR VGND sg13g2_decap_8
XFILLER_28_574 VPWR VGND sg13g2_decap_8
XFILLER_43_533 VPWR VGND sg13g2_decap_8
XFILLER_16_758 VPWR VGND sg13g2_decap_8
XFILLER_8_913 VPWR VGND sg13g2_decap_8
XFILLER_23_290 VPWR VGND sg13g2_decap_8
Xu_ppwm_u_mem__0850_ VGND VPWR u_ppwm_u_mem__0707_/Y net395 u_ppwm_u_mem__1095_/D
+ u_ppwm_u_mem__0849_/Y sg13g2_a21oi_1
XFILLER_12_975 VPWR VGND sg13g2_decap_8
XFILLER_7_456 VPWR VGND sg13g2_decap_8
Xu_ppwm_u_mem__0781_ hold90/A hold140/A net464 u_ppwm_u_mem__0781_/X VPWR VGND sg13g2_mux2_1
XFILLER_3_651 VPWR VGND sg13g2_decap_8
Xu_ppwm_u_mem__1096__158 VPWR VGND net158 sg13g2_tiehi
Xu_ppwm_u_global_counter__110_ VGND VPWR u_ppwm_u_global_counter__120_/B u_ppwm_u_global_counter__120_/C
+ hold289/A net429 sg13g2_a21oi_1
Xu_ppwm_u_ex__1121_ net33 VGND VPWR u_ppwm_u_ex__1121_/D hold8/A clknet_5_18__leaf_clk
+ sg13g2_dfrbpq_2
Xu_ppwm_u_mem__1176__182 VPWR VGND net182 sg13g2_tiehi
Xu_ppwm_u_ex__1052_ u_ppwm_u_ex__1052_/B u_ppwm_u_ex__1065_/B u_ppwm_u_ex__1052_/A
+ u_ppwm_u_ex__1052_/Y VPWR VGND sg13g2_nand3_1
XFILLER_0_42 VPWR VGND sg13g2_decap_8
XFILLER_34_500 VPWR VGND sg13g2_decap_8
Xu_ppwm_u_mem__1195_ net149 VGND VPWR net248 hold30/A clknet_5_19__leaf_clk sg13g2_dfrbpq_1
XFILLER_0_64 VPWR VGND sg13g2_decap_8
XFILLER_19_585 VPWR VGND sg13g2_decap_8
XFILLER_34_577 VPWR VGND sg13g2_decap_8
XFILLER_15_780 VPWR VGND sg13g2_decap_8
XFILLER_22_728 VPWR VGND sg13g2_decap_8
Xu_ppwm_u_ex__0905_ u_ppwm_u_ex__0905_/B u_ppwm_u_ex__1048_/A net345 u_ppwm_u_ex__0905_/Y
+ VPWR VGND u_ppwm_u_ex__0905_/D sg13g2_nand4_1
Xu_ppwm_u_ex__0836_ u_ppwm_u_ex__0835_/Y VPWR u_ppwm_u_ex__0838_/C VGND u_ppwm_u_ex__0790_/Y
+ u_ppwm_u_ex__0834_/Y sg13g2_o21ai_1
XFILLER_30_794 VPWR VGND sg13g2_decap_8
Xu_ppwm_u_ex__0767_ u_ppwm_u_ex__0772_/A hold293/A hold234/A VPWR VGND sg13g2_xnor2_1
Xu_ppwm_u_mem__0979_ net483 VPWR u_ppwm_u_mem__0979_/Y VGND net315 net383 sg13g2_o21ai_1
Xu_ppwm_u_ex__0698_ u_ppwm_u_ex__0699_/B u_ppwm_u_ex__0698_/A u_ppwm_u_ex__0698_/B
+ VPWR VGND sg13g2_nand2_1
Xclkbuf_4_15_0_clk clknet_0_clk clknet_4_15_0_clk VPWR VGND sg13g2_buf_8
XFILLER_45_809 VPWR VGND sg13g2_decap_8
XFILLER_38_861 VPWR VGND sg13g2_decap_8
XFILLER_25_522 VPWR VGND sg13g2_decap_8
XFILLER_37_382 VPWR VGND sg13g2_decap_8
XFILLER_12_227 VPWR VGND sg13g2_fill_2
XFILLER_13_728 VPWR VGND sg13g2_decap_8
XFILLER_25_599 VPWR VGND sg13g2_decap_8
XFILLER_40_569 VPWR VGND sg13g2_decap_8
XFILLER_21_750 VPWR VGND sg13g2_decap_8
XFILLER_20_271 VPWR VGND sg13g2_fill_2
XFILLER_5_916 VPWR VGND sg13g2_decap_8
XFILLER_4_459 VPWR VGND sg13g2_decap_8
XFILLER_0_665 VPWR VGND sg13g2_decap_8
XFILLER_48_625 VPWR VGND sg13g2_decap_8
XFILLER_47_113 VPWR VGND sg13g2_decap_8
XFILLER_29_850 VPWR VGND sg13g2_decap_8
XFILLER_36_809 VPWR VGND sg13g2_decap_8
XFILLER_44_831 VPWR VGND sg13g2_decap_8
XFILLER_16_555 VPWR VGND sg13g2_decap_8
Xu_ppwm_u_ex__1115__28 VPWR VGND net28 sg13g2_tiehi
XFILLER_31_558 VPWR VGND sg13g2_decap_8
Xu_ppwm_u_mem__0902_ VGND VPWR u_ppwm_u_mem__0681_/Y net411 u_ppwm_u_mem__1121_/D
+ u_ppwm_u_mem__0901_/Y sg13g2_a21oi_1
XFILLER_8_710 VPWR VGND sg13g2_decap_8
XFILLER_12_772 VPWR VGND sg13g2_decap_8
XFILLER_15_1025 VPWR VGND sg13g2_decap_4
XFILLER_8_787 VPWR VGND sg13g2_decap_8
Xu_ppwm_u_mem__0833_ u_ppwm_u_mem__0833_/A u_ppwm_u_mem__0833_/B u_ppwm_u_mem__1212_/Q
+ u_ppwm_u_mem__0833_/Y VPWR VGND sg13g2_nor3_1
Xu_ppwm_u_ex__0621_ VGND VPWR u_ppwm_u_ex__0616_/Y u_ppwm_u_ex__0620_/Y u_ppwm_u_ex__1115_/D
+ u_ppwm_u_ex__0782_/A sg13g2_a21oi_1
Xu_ppwm_u_mem__0764_ hold166/A hold149/A net463 u_ppwm_u_mem__0764_/X VPWR VGND sg13g2_mux2_1
XFILLER_7_297 VPWR VGND sg13g2_decap_8
Xhold209 hold209/A VPWR VGND net592 sg13g2_dlygate4sd3_1
Xu_ppwm_u_mem__0695_ VPWR u_ppwm_u_mem__0695_/Y net278 VGND sg13g2_inv_1
XFILLER_39_647 VPWR VGND sg13g2_decap_8
Xu_ppwm_u_ex__1104_ u_ppwm_u_ex__1104_/Y net430 net362 VPWR VGND sg13g2_xnor2_1
XFILLER_38_146 VPWR VGND sg13g2_fill_2
Xu_ppwm_u_ex__1035_ u_ppwm_u_ex__1035_/A u_ppwm_u_ex__1033_/Y u_ppwm_u_ex__1135_/D
+ VPWR VGND sg13g2_nor2b_1
XFILLER_35_842 VPWR VGND sg13g2_decap_8
Xu_ppwm_u_mem__1178_ net175 VGND VPWR u_ppwm_u_mem__1178_/D hold141/A clknet_5_23__leaf_clk
+ sg13g2_dfrbpq_1
XFILLER_34_341 VPWR VGND sg13g2_fill_2
XFILLER_14_18 VPWR VGND sg13g2_decap_8
XFILLER_22_525 VPWR VGND sg13g2_decap_8
XFILLER_30_591 VPWR VGND sg13g2_decap_8
Xu_ppwm_u_ex__0819_ net370 u_ppwm_u_ex__0933_/A u_ppwm_u_ex__0819_/Y VPWR VGND sg13g2_nor2_1
XFILLER_18_809 VPWR VGND sg13g2_decap_8
XFILLER_45_606 VPWR VGND sg13g2_decap_8
XFILLER_40_300 VPWR VGND sg13g2_fill_1
XFILLER_13_525 VPWR VGND sg13g2_decap_8
XFILLER_26_886 VPWR VGND sg13g2_decap_8
XFILLER_41_867 VPWR VGND sg13g2_decap_8
XFILLER_9_507 VPWR VGND sg13g2_decap_8
XFILLER_40_377 VPWR VGND sg13g2_fill_2
XFILLER_5_713 VPWR VGND sg13g2_decap_8
XFILLER_4_289 VPWR VGND sg13g2_fill_2
XFILLER_1_930 VPWR VGND sg13g2_decap_8
XFILLER_49_901 VPWR VGND sg13g2_decap_8
XFILLER_0_462 VPWR VGND sg13g2_decap_8
XFILLER_48_422 VPWR VGND sg13g2_decap_8
XFILLER_49_978 VPWR VGND sg13g2_decap_8
Xhold70 hold70/A VPWR VGND net287 sg13g2_dlygate4sd3_1
Xhold81 hold81/A VPWR VGND net298 sg13g2_dlygate4sd3_1
Xhold92 hold92/A VPWR VGND net309 sg13g2_dlygate4sd3_1
XFILLER_36_606 VPWR VGND sg13g2_decap_8
Xu_ppwm_u_mem__1101_ net148 VGND VPWR u_ppwm_u_mem__1101_/D hold191/A clknet_5_12__leaf_clk
+ sg13g2_dfrbpq_1
XFILLER_48_499 VPWR VGND sg13g2_decap_8
XFILLER_16_330 VPWR VGND sg13g2_fill_1
XFILLER_17_853 VPWR VGND sg13g2_decap_8
Xu_ppwm_u_mem__1032_ VGND VPWR u_ppwm_u_mem__0616_/Y net410 u_ppwm_u_mem__1186_/D
+ u_ppwm_u_mem__1031_/Y sg13g2_a21oi_1
XFILLER_45_91 VPWR VGND sg13g2_decap_8
XFILLER_16_385 VPWR VGND sg13g2_fill_1
XFILLER_32_823 VPWR VGND sg13g2_decap_8
XFILLER_31_322 VPWR VGND sg13g2_fill_1
XFILLER_8_584 VPWR VGND sg13g2_decap_8
Xu_ppwm_u_ex__0604_ VPWR u_ppwm_u_ex__0604_/Y hold288/A VGND sg13g2_inv_1
Xu_ppwm_u_mem__0816_ u_ppwm_u_mem__0815_/Y VPWR fanout371/A VGND u_ppwm_u_mem__0808_/Y
+ u_ppwm_u_mem__0809_/Y sg13g2_o21ai_1
Xu_ppwm_u_mem__0747_ hold57/A hold22/A net464 u_ppwm_u_mem__0747_/X VPWR VGND sg13g2_mux2_1
Xu_ppwm_u_mem__0678_ VPWR u_ppwm_u_mem__0678_/Y net289 VGND sg13g2_inv_1
XFILLER_6_1023 VPWR VGND sg13g2_decap_4
XFILLER_27_617 VPWR VGND sg13g2_decap_8
Xu_ppwm_u_ex__1018_ u_ppwm_u_ex__1018_/A u_ppwm_u_ex__1018_/B u_ppwm_u_ex__1023_/A
+ VPWR VGND sg13g2_nor2_1
XFILLER_22_300 VPWR VGND sg13g2_decap_4
XFILLER_23_812 VPWR VGND sg13g2_decap_8
XFILLER_23_889 VPWR VGND sg13g2_decap_8
XFILLER_22_388 VPWR VGND sg13g2_fill_2
XFILLER_49_208 VPWR VGND sg13g2_fill_2
XFILLER_18_606 VPWR VGND sg13g2_decap_8
XFILLER_46_937 VPWR VGND sg13g2_decap_8
XFILLER_26_683 VPWR VGND sg13g2_decap_8
XFILLER_32_119 VPWR VGND sg13g2_decap_8
XFILLER_14_856 VPWR VGND sg13g2_decap_8
XFILLER_41_664 VPWR VGND sg13g2_decap_8
XFILLER_40_163 VPWR VGND sg13g2_fill_1
XFILLER_40_196 VPWR VGND sg13g2_decap_4
XFILLER_12_1017 VPWR VGND sg13g2_decap_8
XFILLER_5_510 VPWR VGND sg13g2_decap_8
XFILLER_12_1028 VPWR VGND sg13g2_fill_1
XFILLER_5_587 VPWR VGND sg13g2_decap_8
Xoutput3 net3 uo_out[0] VPWR VGND sg13g2_buf_1
Xu_ppwm_u_mem__0601_ VPWR u_ppwm_u_mem__0718_/C net560 VGND sg13g2_inv_1
XFILLER_49_775 VPWR VGND sg13g2_decap_8
XFILLER_36_436 VPWR VGND sg13g2_fill_2
XFILLER_37_959 VPWR VGND sg13g2_decap_8
XFILLER_17_650 VPWR VGND sg13g2_decap_8
XFILLER_45_970 VPWR VGND sg13g2_decap_8
Xu_ppwm_u_mem__1015_ net503 VPWR u_ppwm_u_mem__1015_/Y VGND net309 net408 sg13g2_o21ai_1
XFILLER_32_620 VPWR VGND sg13g2_decap_8
XFILLER_20_804 VPWR VGND sg13g2_decap_8
XFILLER_32_697 VPWR VGND sg13g2_decap_8
XFILLER_9_871 VPWR VGND sg13g2_decap_8
XFILLER_11_19 VPWR VGND sg13g2_fill_1
Xfanout349 fanout349/A net349 VPWR VGND sg13g2_buf_8
XFILLER_28_959 VPWR VGND sg13g2_decap_8
XFILLER_43_918 VPWR VGND sg13g2_decap_8
XFILLER_14_108 VPWR VGND sg13g2_fill_2
XFILLER_36_970 VPWR VGND sg13g2_decap_8
XFILLER_11_815 VPWR VGND sg13g2_decap_8
XFILLER_35_1017 VPWR VGND sg13g2_decap_8
XFILLER_35_1028 VPWR VGND sg13g2_fill_1
XFILLER_23_686 VPWR VGND sg13g2_decap_8
XFILLER_7_4 VPWR VGND sg13g2_fill_2
XFILLER_2_557 VPWR VGND sg13g2_decap_8
XFILLER_46_734 VPWR VGND sg13g2_decap_8
XFILLER_18_414 VPWR VGND sg13g2_fill_2
XFILLER_45_277 VPWR VGND sg13g2_fill_2
XFILLER_27_981 VPWR VGND sg13g2_decap_8
XFILLER_33_406 VPWR VGND sg13g2_fill_2
XFILLER_26_480 VPWR VGND sg13g2_decap_8
XFILLER_42_951 VPWR VGND sg13g2_decap_8
XFILLER_13_141 VPWR VGND sg13g2_fill_1
XFILLER_14_653 VPWR VGND sg13g2_decap_8
XFILLER_41_461 VPWR VGND sg13g2_decap_8
XFILLER_13_185 VPWR VGND sg13g2_fill_2
XFILLER_42_92 VPWR VGND sg13g2_fill_1
Xu_ppwm_u_pwm__254_ net204 VGND VPWR net576 hold192/A clknet_5_1__leaf_clk sg13g2_dfrbpq_1
Xu_ppwm_u_pwm__185_ VGND VPWR u_ppwm_u_pwm__135_/Y net379 hold198/A u_ppwm_u_pwm__184_/Y
+ sg13g2_a21oi_1
XFILLER_6_841 VPWR VGND sg13g2_decap_8
XFILLER_49_572 VPWR VGND sg13g2_decap_8
XFILLER_3_1015 VPWR VGND sg13g2_decap_8
XFILLER_36_200 VPWR VGND sg13g2_decap_8
XFILLER_25_907 VPWR VGND sg13g2_decap_8
XFILLER_37_756 VPWR VGND sg13g2_decap_8
XFILLER_18_970 VPWR VGND sg13g2_decap_8
XFILLER_24_439 VPWR VGND sg13g2_decap_8
XFILLER_20_601 VPWR VGND sg13g2_decap_8
XFILLER_33_984 VPWR VGND sg13g2_decap_8
Xu_ppwm_u_ex__0998_ VPWR VGND net350 u_ppwm_u_ex__0992_/Y u_ppwm_u_ex__0997_/X net373
+ u_ppwm_u_ex__0998_/Y u_ppwm_u_ex__0860_/B sg13g2_a221oi_1
XFILLER_32_494 VPWR VGND sg13g2_decap_8
XFILLER_20_678 VPWR VGND sg13g2_decap_8
XFILLER_41_1021 VPWR VGND sg13g2_decap_8
Xu_ppwm_u_mem__1193__177 VPWR VGND net177 sg13g2_tiehi
XFILLER_28_756 VPWR VGND sg13g2_decap_8
XFILLER_43_715 VPWR VGND sg13g2_decap_8
XFILLER_15_406 VPWR VGND sg13g2_decap_4
Xu_ppwm_u_ex__1139__45 VPWR VGND net45 sg13g2_tiehi
XFILLER_27_277 VPWR VGND sg13g2_decap_4
XFILLER_15_439 VPWR VGND sg13g2_decap_4
XFILLER_42_269 VPWR VGND sg13g2_fill_1
XFILLER_11_612 VPWR VGND sg13g2_decap_8
XFILLER_23_483 VPWR VGND sg13g2_decap_8
XFILLER_7_638 VPWR VGND sg13g2_decap_8
XFILLER_11_689 VPWR VGND sg13g2_decap_8
XFILLER_6_137 VPWR VGND sg13g2_decap_4
XFILLER_3_833 VPWR VGND sg13g2_decap_8
XFILLER_46_531 VPWR VGND sg13g2_decap_8
XFILLER_19_767 VPWR VGND sg13g2_decap_8
XFILLER_34_759 VPWR VGND sg13g2_decap_8
XFILLER_14_450 VPWR VGND sg13g2_decap_8
XFILLER_15_962 VPWR VGND sg13g2_decap_8
XFILLER_18_1012 VPWR VGND sg13g2_decap_8
Xu_ppwm_u_ex__0921_ VGND VPWR net434 u_ppwm_u_ex__0785_/Y u_ppwm_u_ex__0922_/D u_ppwm_u_ex__0920_/Y
+ sg13g2_a21oi_1
Xu_ppwm_u_ex__0852_ u_ppwm_u_ex__0822_/X u_ppwm_u_ex__0851_/X net368 u_ppwm_u_ex__0966_/B
+ VPWR VGND sg13g2_mux2_1
Xu_ppwm_u_ex__0783_ fanout354/A u_ppwm/instr\[2\] u_ppwm_u_ex__0812_/B VPWR VGND sg13g2_nand2_1
XFILLER_30_976 VPWR VGND sg13g2_decap_8
Xu_ppwm_u_mem__0995_ net492 VPWR u_ppwm_u_mem__0995_/Y VGND hold158/A net385 sg13g2_o21ai_1
Xu_ppwm_u_pwm__237_ net203 VGND VPWR u_ppwm_u_pwm__237_/D hold229/A clknet_5_1__leaf_clk
+ sg13g2_dfrbpq_2
Xu_ppwm_u_pwm__168_ u_ppwm_u_pwm__169_/B net628 u_ppwm_u_pwm__171_/C VPWR VGND sg13g2_xnor2_1
XFILLER_25_1005 VPWR VGND sg13g2_decap_8
XFILLER_17_18 VPWR VGND sg13g2_fill_2
XFILLER_25_704 VPWR VGND sg13g2_decap_8
Xu_ppwm_u_mem__1114__123 VPWR VGND net123 sg13g2_tiehi
XFILLER_37_553 VPWR VGND sg13g2_decap_8
XFILLER_21_932 VPWR VGND sg13g2_decap_8
XFILLER_33_781 VPWR VGND sg13g2_decap_8
XFILLER_20_453 VPWR VGND sg13g2_fill_2
XFILLER_20_475 VPWR VGND sg13g2_decap_8
XFILLER_0_847 VPWR VGND sg13g2_decap_8
Xu_ppwm_u_mem__1201__173 VPWR VGND net173 sg13g2_tiehi
XFILLER_48_807 VPWR VGND sg13g2_decap_8
XFILLER_47_306 VPWR VGND sg13g2_fill_1
XFILLER_28_553 VPWR VGND sg13g2_decap_8
XFILLER_43_512 VPWR VGND sg13g2_decap_8
XFILLER_15_225 VPWR VGND sg13g2_fill_2
XFILLER_16_737 VPWR VGND sg13g2_decap_8
XFILLER_43_589 VPWR VGND sg13g2_decap_8
Xu_ppwm_u_ex__1127__48 VPWR VGND net48 sg13g2_tiehi
XFILLER_12_954 VPWR VGND sg13g2_decap_8
XFILLER_8_969 VPWR VGND sg13g2_decap_8
XFILLER_7_435 VPWR VGND sg13g2_fill_1
XFILLER_11_486 VPWR VGND sg13g2_decap_8
Xu_ppwm_u_mem__0780_ hold176/A hold144/A net474 u_ppwm_u_mem__0780_/X VPWR VGND sg13g2_mux2_1
XFILLER_3_630 VPWR VGND sg13g2_decap_8
XFILLER_2_140 VPWR VGND sg13g2_fill_2
Xu_ppwm_u_ex__1120_ net35 VGND VPWR net513 hold129/A clknet_5_16__leaf_clk sg13g2_dfrbpq_1
XFILLER_39_829 VPWR VGND sg13g2_decap_8
Xu_ppwm_u_ex__1051_ u_ppwm_u_ex__1065_/B net434 net365 VPWR VGND sg13g2_xnor2_1
XFILLER_47_884 VPWR VGND sg13g2_decap_8
XFILLER_0_21 VPWR VGND sg13g2_decap_8
XFILLER_19_564 VPWR VGND sg13g2_decap_8
Xu_ppwm_u_mem__1194_ net165 VGND VPWR u_ppwm_u_mem__1194_/D hold119/A clknet_5_22__leaf_clk
+ sg13g2_dfrbpq_1
XFILLER_0_87 VPWR VGND sg13g2_decap_8
XFILLER_22_707 VPWR VGND sg13g2_decap_8
XFILLER_34_556 VPWR VGND sg13g2_decap_8
XFILLER_21_206 VPWR VGND sg13g2_fill_2
Xu_ppwm_u_ex__0904_ VGND VPWR net435 u_ppwm_u_ex__0785_/Y u_ppwm_u_ex__0905_/D u_ppwm_u_ex__0903_/Y
+ sg13g2_a21oi_1
XFILLER_21_239 VPWR VGND sg13g2_fill_1
XFILLER_30_773 VPWR VGND sg13g2_decap_8
Xu_ppwm_u_ex__0835_ VGND VPWR u_ppwm_u_ex__0790_/Y u_ppwm_u_ex__0834_/Y u_ppwm_u_ex__0835_/Y
+ net349 sg13g2_a21oi_1
XFILLER_31_1020 VPWR VGND sg13g2_decap_8
Xu_ppwm_u_ex__0766_ u_ppwm_u_ex__0773_/C hold234/A net430 VPWR VGND sg13g2_nand2b_1
Xu_ppwm_u_mem__0978_ VGND VPWR u_ppwm_u_mem__0643_/Y net382 hold82/A u_ppwm_u_mem__0977_/Y
+ sg13g2_a21oi_1
Xu_ppwm_u_ex__0697_ u_ppwm_u_ex__0698_/B u_ppwm_u_ex__0721_/A hold275/A u_ppwm_u_ex__0896_/A
+ hold298/A VPWR VGND sg13g2_a22oi_1
XFILLER_29_317 VPWR VGND sg13g2_fill_2
XFILLER_38_840 VPWR VGND sg13g2_decap_8
XFILLER_25_501 VPWR VGND sg13g2_decap_8
XFILLER_44_16 VPWR VGND sg13g2_decap_4
Xu_ppwm_u_global_counter__169_ net68 VGND VPWR u_ppwm_u_global_counter__169_/D hold234/A
+ clknet_5_16__leaf_clk sg13g2_dfrbpq_2
XFILLER_13_707 VPWR VGND sg13g2_decap_8
XFILLER_25_578 VPWR VGND sg13g2_decap_8
XFILLER_40_548 VPWR VGND sg13g2_decap_8
XFILLER_4_438 VPWR VGND sg13g2_decap_8
XFILLER_0_644 VPWR VGND sg13g2_decap_8
XFILLER_48_604 VPWR VGND sg13g2_decap_8
XFILLER_28_350 VPWR VGND sg13g2_fill_1
XFILLER_44_810 VPWR VGND sg13g2_decap_8
XFILLER_16_534 VPWR VGND sg13g2_decap_8
XFILLER_43_331 VPWR VGND sg13g2_fill_1
XFILLER_44_887 VPWR VGND sg13g2_decap_8
XFILLER_43_386 VPWR VGND sg13g2_decap_8
XFILLER_15_1004 VPWR VGND sg13g2_decap_8
XFILLER_31_537 VPWR VGND sg13g2_decap_8
XFILLER_34_82 VPWR VGND sg13g2_fill_1
Xu_ppwm_u_mem__0901_ net500 VPWR u_ppwm_u_mem__0901_/Y VGND net227 net411 sg13g2_o21ai_1
XFILLER_11_250 VPWR VGND sg13g2_decap_4
XFILLER_12_751 VPWR VGND sg13g2_decap_8
XFILLER_8_766 VPWR VGND sg13g2_decap_8
XFILLER_7_243 VPWR VGND sg13g2_decap_8
XFILLER_11_294 VPWR VGND sg13g2_decap_8
Xu_ppwm_u_ex__0620_ u_ppwm_u_ex__0620_/B u_ppwm_u_ex__0652_/A net475 u_ppwm_u_ex__0620_/Y
+ VPWR VGND sg13g2_nand3_1
Xu_ppwm_u_mem__0832_ u_ppwm_u_mem__0831_/Y VPWR fanout367/A VGND u_ppwm_u_mem__0824_/Y
+ u_ppwm_u_mem__0825_/Y sg13g2_o21ai_1
Xu_ppwm_u_mem__0763_ hold78/A hold48/A net473 u_ppwm_u_mem__0763_/X VPWR VGND sg13g2_mux2_1
Xu_ppwm_u_mem__0694_ VPWR u_ppwm_u_mem__0694_/Y net507 VGND sg13g2_inv_1
XFILLER_39_626 VPWR VGND sg13g2_decap_8
XFILLER_22_4 VPWR VGND sg13g2_decap_8
Xu_ppwm_u_ex__1103_ VGND VPWR u_ppwm_u_ex__1091_/Y u_ppwm_u_ex__1093_/X u_ppwm_u_ex__1103_/Y
+ u_ppwm_u_ex__1092_/X sg13g2_a21oi_1
XFILLER_22_1008 VPWR VGND sg13g2_decap_8
Xu_ppwm_u_ex__1034_ net495 VPWR u_ppwm_u_ex__1035_/A VGND net627 net342 sg13g2_o21ai_1
XFILLER_26_309 VPWR VGND sg13g2_fill_1
XFILLER_47_681 VPWR VGND sg13g2_decap_8
XFILLER_35_821 VPWR VGND sg13g2_decap_8
Xu_ppwm_u_mem__1177_ net179 VGND VPWR u_ppwm_u_mem__1177_/D hold199/A clknet_5_29__leaf_clk
+ sg13g2_dfrbpq_1
XFILLER_22_504 VPWR VGND sg13g2_decap_8
XFILLER_34_375 VPWR VGND sg13g2_fill_2
XFILLER_35_898 VPWR VGND sg13g2_decap_8
XFILLER_30_570 VPWR VGND sg13g2_decap_8
Xu_ppwm_u_ex__0818_ VGND VPWR u_ppwm_u_ex__0795_/Y u_ppwm_u_ex__0816_/Y u_ppwm_u_ex__1122_/D
+ u_ppwm_u_ex__0817_/Y sg13g2_a21oi_1
Xu_ppwm_u_ex__0749_ u_ppwm_u_ex__0750_/C hold259/A net430 VPWR VGND sg13g2_nand2b_1
XFILLER_1_419 VPWR VGND sg13g2_decap_8
XFILLER_26_865 VPWR VGND sg13g2_decap_8
XFILLER_13_504 VPWR VGND sg13g2_decap_8
XFILLER_38_1015 VPWR VGND sg13g2_decap_8
XFILLER_41_846 VPWR VGND sg13g2_decap_8
XFILLER_5_769 VPWR VGND sg13g2_decap_8
XFILLER_45_1019 VPWR VGND sg13g2_decap_8
XFILLER_48_401 VPWR VGND sg13g2_decap_8
XFILLER_0_441 VPWR VGND sg13g2_decap_8
XFILLER_1_986 VPWR VGND sg13g2_decap_8
XFILLER_49_957 VPWR VGND sg13g2_decap_8
XFILLER_29_60 VPWR VGND sg13g2_fill_2
XFILLER_48_478 VPWR VGND sg13g2_decap_8
Xhold60 hold60/A VPWR VGND net277 sg13g2_dlygate4sd3_1
Xu_ppwm_u_mem__1100_ net150 VGND VPWR net570 hold186/A clknet_5_11__leaf_clk sg13g2_dfrbpq_1
Xhold71 hold71/A VPWR VGND net288 sg13g2_dlygate4sd3_1
Xhold82 hold82/A VPWR VGND net299 sg13g2_dlygate4sd3_1
XFILLER_17_832 VPWR VGND sg13g2_decap_8
Xhold93 hold93/A VPWR VGND net310 sg13g2_dlygate4sd3_1
XFILLER_28_191 VPWR VGND sg13g2_decap_4
Xu_ppwm_u_mem__1031_ net499 VPWR u_ppwm_u_mem__1031_/Y VGND net284 net405 sg13g2_o21ai_1
XFILLER_44_684 VPWR VGND sg13g2_decap_8
XFILLER_32_802 VPWR VGND sg13g2_decap_8
XFILLER_32_879 VPWR VGND sg13g2_decap_8
Xclkbuf_4_14_0_clk clknet_0_clk clknet_4_14_0_clk VPWR VGND sg13g2_buf_8
XFILLER_8_563 VPWR VGND sg13g2_decap_8
Xu_ppwm_u_ex__0603_ VPWR u_ppwm_u_ex__0603_/Y net427 VGND sg13g2_inv_1
XFILLER_6_31 VPWR VGND sg13g2_fill_2
Xu_ppwm_u_mem__0815_ u_ppwm_u_mem__0815_/Y u_ppwm_u_mem__0831_/A u_ppwm_u_mem__0815_/B
+ VPWR VGND sg13g2_nand2_1
XFILLER_6_75 VPWR VGND sg13g2_decap_8
XFILLER_6_64 VPWR VGND sg13g2_fill_1
Xu_ppwm_u_mem__0746_ hold142/A hold28/A net463 u_ppwm_u_mem__0746_/X VPWR VGND sg13g2_mux2_1
Xu_ppwm_u_mem__0677_ VPWR u_ppwm_u_mem__0677_/Y net508 VGND sg13g2_inv_1
XFILLER_39_401 VPWR VGND sg13g2_fill_2
XFILLER_6_1002 VPWR VGND sg13g2_decap_8
Xu_ppwm_u_ex__1017_ fanout350/A VPWR u_ppwm_u_ex__1018_/B VGND u_ppwm_u_ex__1016_/A
+ u_ppwm_u_ex__1016_/B sg13g2_o21ai_1
XFILLER_22_323 VPWR VGND sg13g2_decap_8
XFILLER_35_695 VPWR VGND sg13g2_decap_8
XFILLER_22_356 VPWR VGND sg13g2_decap_4
XFILLER_23_868 VPWR VGND sg13g2_decap_8
XFILLER_41_17 VPWR VGND sg13g2_decap_8
XFILLER_2_739 VPWR VGND sg13g2_decap_8
XFILLER_46_916 VPWR VGND sg13g2_decap_8
XFILLER_39_990 VPWR VGND sg13g2_decap_8
XFILLER_45_459 VPWR VGND sg13g2_decap_8
XFILLER_26_662 VPWR VGND sg13g2_decap_8
XFILLER_41_643 VPWR VGND sg13g2_decap_8
XFILLER_14_835 VPWR VGND sg13g2_decap_8
XFILLER_40_131 VPWR VGND sg13g2_decap_8
Xu_ppwm_u_mem__0600_ VPWR u_ppwm_u_mem__0833_/A net610 VGND sg13g2_inv_1
XFILLER_5_566 VPWR VGND sg13g2_decap_8
XFILLER_0_282 VPWR VGND sg13g2_decap_8
XFILLER_0_271 VPWR VGND sg13g2_fill_1
XFILLER_0_260 VPWR VGND sg13g2_decap_8
XFILLER_1_783 VPWR VGND sg13g2_decap_8
XFILLER_49_754 VPWR VGND sg13g2_decap_8
XFILLER_37_938 VPWR VGND sg13g2_decap_8
Xu_ppwm_u_mem__1014_ VGND VPWR u_ppwm_u_mem__0625_/Y net409 u_ppwm_u_mem__1177_/D
+ u_ppwm_u_mem__1013_/Y sg13g2_a21oi_1
XFILLER_44_481 VPWR VGND sg13g2_decap_8
XFILLER_31_131 VPWR VGND sg13g2_fill_1
XFILLER_32_676 VPWR VGND sg13g2_decap_8
XFILLER_9_850 VPWR VGND sg13g2_decap_8
XFILLER_8_382 VPWR VGND sg13g2_decap_4
Xu_ppwm_u_mem__0729_ net451 VPWR u_ppwm_u_mem__0729_/Y VGND u_ppwm_u_mem__0725_/Y
+ u_ppwm_u_mem__0728_/Y sg13g2_o21ai_1
XFILLER_39_264 VPWR VGND sg13g2_fill_1
XFILLER_27_404 VPWR VGND sg13g2_fill_1
XFILLER_28_938 VPWR VGND sg13g2_decap_8
XFILLER_36_28 VPWR VGND sg13g2_decap_4
XFILLER_35_492 VPWR VGND sg13g2_decap_8
XFILLER_23_665 VPWR VGND sg13g2_decap_8
XFILLER_22_153 VPWR VGND sg13g2_fill_1
XFILLER_22_197 VPWR VGND sg13g2_fill_2
Xu_ppwm_u_mem__1124__103 VPWR VGND net103 sg13g2_tiehi
XFILLER_2_536 VPWR VGND sg13g2_decap_8
XFILLER_46_713 VPWR VGND sg13g2_decap_8
XFILLER_19_949 VPWR VGND sg13g2_decap_8
XFILLER_27_960 VPWR VGND sg13g2_decap_8
XFILLER_42_930 VPWR VGND sg13g2_decap_8
XFILLER_14_632 VPWR VGND sg13g2_decap_8
XFILLER_13_131 VPWR VGND sg13g2_fill_1
XFILLER_42_71 VPWR VGND sg13g2_fill_2
Xu_ppwm_u_pwm__253_ net214 VGND VPWR net587 hold203/A clknet_5_1__leaf_clk sg13g2_dfrbpq_1
XFILLER_6_820 VPWR VGND sg13g2_decap_8
Xu_ppwm_u_pwm__184_ net478 VPWR u_ppwm_u_pwm__184_/Y VGND net447 net378 sg13g2_o21ai_1
XFILLER_6_897 VPWR VGND sg13g2_decap_8
XFILLER_1_580 VPWR VGND sg13g2_decap_8
XFILLER_49_551 VPWR VGND sg13g2_decap_8
XFILLER_36_234 VPWR VGND sg13g2_fill_1
XFILLER_37_735 VPWR VGND sg13g2_decap_8
XFILLER_33_963 VPWR VGND sg13g2_decap_8
XFILLER_20_657 VPWR VGND sg13g2_decap_8
Xu_ppwm_u_ex__0997_ net373 net647 u_ppwm_u_ex__0997_/X VPWR VGND sg13g2_xor2_1
Xclkbuf_5_28__f_clk clknet_4_14_0_clk clknet_5_28__leaf_clk VPWR VGND sg13g2_buf_8
XFILLER_41_1000 VPWR VGND sg13g2_decap_8
XFILLER_28_735 VPWR VGND sg13g2_decap_8
XFILLER_16_919 VPWR VGND sg13g2_decap_8
XFILLER_27_267 VPWR VGND sg13g2_fill_1
XFILLER_23_462 VPWR VGND sg13g2_decap_8
XFILLER_24_985 VPWR VGND sg13g2_decap_8
XFILLER_7_617 VPWR VGND sg13g2_decap_8
XFILLER_11_668 VPWR VGND sg13g2_decap_8
XFILLER_3_812 VPWR VGND sg13g2_decap_8
XFILLER_12_74 VPWR VGND sg13g2_fill_2
XFILLER_3_889 VPWR VGND sg13g2_decap_8
Xhold190 hold190/A VPWR VGND net573 sg13g2_dlygate4sd3_1
XFILLER_46_510 VPWR VGND sg13g2_decap_8
XFILLER_19_746 VPWR VGND sg13g2_decap_8
XFILLER_46_587 VPWR VGND sg13g2_decap_8
XFILLER_18_289 VPWR VGND sg13g2_fill_2
XFILLER_34_738 VPWR VGND sg13g2_decap_8
Xu_ppwm_u_ex__0920_ net354 u_ppwm_u_ex__0920_/B u_ppwm_u_ex__0920_/Y VPWR VGND sg13g2_nor2_1
XFILLER_15_941 VPWR VGND sg13g2_decap_8
Xu_ppwm_u_ex__0851_ net442 net433 net376 u_ppwm_u_ex__0851_/X VPWR VGND sg13g2_mux2_1
XFILLER_30_955 VPWR VGND sg13g2_decap_8
Xu_ppwm_u_ex__0782_ u_ppwm_u_ex__0782_/A u_ppwm_u_ex__0782_/B u_ppwm_u_ex__1121_/D
+ VPWR VGND sg13g2_nor2_1
Xu_ppwm_u_mem__0994_ VGND VPWR u_ppwm_u_mem__0635_/Y net386 u_ppwm_u_mem__1167_/D
+ u_ppwm_u_mem__0993_/Y sg13g2_a21oi_1
Xu_ppwm_u_pwm__236_ net205 VGND VPWR net598 hold213/A clknet_5_0__leaf_clk sg13g2_dfrbpq_2
Xu_ppwm_u_pwm__167_ u_ppwm_u_pwm__175_/A net620 u_ppwm_u_pwm__171_/C hold238/A VPWR
+ VGND sg13g2_nor3_1
XFILLER_6_694 VPWR VGND sg13g2_decap_8
XFILLER_25_1028 VPWR VGND sg13g2_fill_1
XFILLER_37_532 VPWR VGND sg13g2_decap_8
XFILLER_21_911 VPWR VGND sg13g2_decap_8
XFILLER_33_760 VPWR VGND sg13g2_decap_8
XFILLER_21_988 VPWR VGND sg13g2_decap_8
XFILLER_3_108 VPWR VGND sg13g2_decap_8
XFILLER_0_826 VPWR VGND sg13g2_decap_8
Xheichips25_ppwm_20 VPWR VGND uo_out[1] sg13g2_tielo
XFILLER_28_532 VPWR VGND sg13g2_decap_8
XFILLER_16_716 VPWR VGND sg13g2_decap_8
XFILLER_43_568 VPWR VGND sg13g2_decap_8
XFILLER_24_782 VPWR VGND sg13g2_decap_8
XFILLER_31_719 VPWR VGND sg13g2_decap_8
XFILLER_12_933 VPWR VGND sg13g2_decap_8
XFILLER_23_281 VPWR VGND sg13g2_fill_1
XFILLER_8_948 VPWR VGND sg13g2_decap_8
XFILLER_23_62 VPWR VGND sg13g2_fill_1
XFILLER_48_1017 VPWR VGND sg13g2_decap_8
XFILLER_48_1028 VPWR VGND sg13g2_fill_1
XFILLER_3_686 VPWR VGND sg13g2_decap_8
XFILLER_39_808 VPWR VGND sg13g2_decap_8
Xclkbuf_5_11__f_clk clknet_4_5_0_clk clknet_5_11__leaf_clk VPWR VGND sg13g2_buf_8
XFILLER_48_81 VPWR VGND sg13g2_decap_8
Xu_ppwm_u_ex__1050_ u_ppwm_u_ex__1050_/A u_ppwm_u_ex__1048_/Y u_ppwm_u_ex__1136_/D
+ VPWR VGND sg13g2_nor2b_1
XFILLER_47_863 VPWR VGND sg13g2_decap_8
XFILLER_0_1008 VPWR VGND sg13g2_decap_8
XFILLER_19_543 VPWR VGND sg13g2_decap_8
Xu_ppwm_u_mem__1193_ net177 VGND VPWR net242 hold24/A clknet_5_19__leaf_clk sg13g2_dfrbpq_1
XFILLER_34_535 VPWR VGND sg13g2_decap_8
Xu_ppwm_u_ex__0903_ net354 u_ppwm_u_ex__0903_/B u_ppwm_u_ex__0903_/Y VPWR VGND sg13g2_nor2_1
Xu_ppwm_u_ex__0834_ u_ppwm_u_ex__0834_/Y net449 net370 VPWR VGND sg13g2_xnor2_1
XFILLER_30_752 VPWR VGND sg13g2_decap_8
Xu_ppwm_u_pwm__219_ u_ppwm_u_pwm__222_/C hold70/A hold236/A VPWR VGND sg13g2_nand2b_1
Xu_ppwm_u_ex__0765_ VPWR VGND u_ppwm_u_ex__0763_/Y u_ppwm_u_ex__0764_/Y u_ppwm_u_ex__0762_/Y
+ u_ppwm_u_ex__0769_/A u_ppwm_u_ex__0765_/Y net425 sg13g2_a221oi_1
Xu_ppwm_u_mem__0977_ net481 VPWR u_ppwm_u_mem__0977_/Y VGND hold109/A net382 sg13g2_o21ai_1
XFILLER_7_981 VPWR VGND sg13g2_decap_8
Xu_ppwm_u_ex__0696_ u_ppwm_u_ex__0698_/A hold293/A u_ppwm_u_ex__0719_/A VPWR VGND
+ sg13g2_nand2_1
XFILLER_43_0 VPWR VGND sg13g2_decap_8
XFILLER_6_491 VPWR VGND sg13g2_decap_8
XFILLER_9_1011 VPWR VGND sg13g2_decap_8
XFILLER_28_18 VPWR VGND sg13g2_decap_4
Xu_ppwm_u_global_counter__168_ net70 VGND VPWR u_ppwm_u_global_counter__168_/D hold282/A
+ clknet_5_5__leaf_clk sg13g2_dfrbpq_2
XFILLER_38_896 VPWR VGND sg13g2_decap_8
Xu_ppwm_u_global_counter__099_ VPWR fanout429/A net494 VGND sg13g2_inv_1
XFILLER_25_557 VPWR VGND sg13g2_decap_8
XFILLER_40_527 VPWR VGND sg13g2_decap_8
XFILLER_12_229 VPWR VGND sg13g2_fill_1
XFILLER_20_273 VPWR VGND sg13g2_fill_1
XFILLER_21_785 VPWR VGND sg13g2_decap_8
XFILLER_4_417 VPWR VGND sg13g2_decap_8
XFILLER_0_623 VPWR VGND sg13g2_decap_8
Xu_ppwm_u_mem__1095__160 VPWR VGND net160 sg13g2_tiehi
XFILLER_16_513 VPWR VGND sg13g2_decap_8
XFILLER_29_885 VPWR VGND sg13g2_decap_8
XFILLER_44_866 VPWR VGND sg13g2_decap_8
XFILLER_31_516 VPWR VGND sg13g2_decap_8
XFILLER_12_730 VPWR VGND sg13g2_decap_8
Xu_ppwm_u_mem__0900_ VGND VPWR u_ppwm_u_mem__0682_/Y net413 u_ppwm_u_mem__1120_/D
+ u_ppwm_u_mem__0899_/Y sg13g2_a21oi_1
XFILLER_8_745 VPWR VGND sg13g2_decap_8
Xu_ppwm_u_mem__0831_ u_ppwm_u_mem__0831_/Y u_ppwm_u_mem__0831_/A u_ppwm_u_mem__0831_/B
+ VPWR VGND sg13g2_nand2_1
Xu_ppwm_u_mem__0762_ hold37/A hold125/A net463 u_ppwm_u_mem__0762_/X VPWR VGND sg13g2_mux2_1
Xu_ppwm_u_mem__1143__183 VPWR VGND net183 sg13g2_tiehi
Xu_ppwm_u_mem__0693_ VPWR u_ppwm_u_mem__0693_/Y net286 VGND sg13g2_inv_1
XFILLER_4_984 VPWR VGND sg13g2_decap_8
XFILLER_3_483 VPWR VGND sg13g2_decap_8
XFILLER_39_605 VPWR VGND sg13g2_decap_8
XFILLER_15_4 VPWR VGND sg13g2_decap_8
Xu_ppwm_u_ex__1102_ u_ppwm_u_ex__1102_/A u_ppwm_u_ex__1102_/B u_ppwm_u_ex__1140_/D
+ VPWR VGND sg13g2_nor2_1
Xu_ppwm_u_ex__1033_ net342 u_ppwm_u_ex__1033_/C u_ppwm_u_ex__1033_/A u_ppwm_u_ex__1033_/Y
+ VPWR VGND u_ppwm_u_ex__1033_/D sg13g2_nand4_1
XFILLER_35_800 VPWR VGND sg13g2_decap_8
XFILLER_47_660 VPWR VGND sg13g2_decap_8
XFILLER_19_351 VPWR VGND sg13g2_decap_8
Xu_ppwm_u_mem__1176_ net182 VGND VPWR net529 hold145/A clknet_5_29__leaf_clk sg13g2_dfrbpq_1
XFILLER_35_877 VPWR VGND sg13g2_decap_8
Xu_ppwm_u_ex__0817_ net496 VPWR u_ppwm_u_ex__0817_/Y VGND net450 net345 sg13g2_o21ai_1
Xu_ppwm_u_ex__0748_ net369 u_ppwm_u_ex__0773_/B fanout356/A VPWR VGND sg13g2_and2_1
Xu_ppwm_u_ex__0679_ u_ppwm_u_ex__0679_/Y net446 net438 VPWR VGND sg13g2_nand2b_1
XFILLER_26_844 VPWR VGND sg13g2_decap_8
XFILLER_38_693 VPWR VGND sg13g2_decap_8
XFILLER_41_825 VPWR VGND sg13g2_decap_8
XFILLER_21_582 VPWR VGND sg13g2_decap_8
XFILLER_5_748 VPWR VGND sg13g2_decap_8
XFILLER_20_52 VPWR VGND sg13g2_fill_1
XFILLER_4_269 VPWR VGND sg13g2_decap_8
XFILLER_0_420 VPWR VGND sg13g2_decap_8
XFILLER_1_965 VPWR VGND sg13g2_decap_8
XFILLER_49_936 VPWR VGND sg13g2_decap_8
Xhold50 hold50/A VPWR VGND net267 sg13g2_dlygate4sd3_1
XFILLER_0_497 VPWR VGND sg13g2_decap_8
XFILLER_48_457 VPWR VGND sg13g2_decap_8
Xhold72 hold72/A VPWR VGND net289 sg13g2_dlygate4sd3_1
Xhold83 hold83/A VPWR VGND net300 sg13g2_dlygate4sd3_1
Xhold61 hold61/A VPWR VGND net278 sg13g2_dlygate4sd3_1
Xhold94 hold94/A VPWR VGND net311 sg13g2_dlygate4sd3_1
XFILLER_17_811 VPWR VGND sg13g2_decap_8
XFILLER_29_682 VPWR VGND sg13g2_decap_8
Xu_ppwm_u_mem__1030_ VGND VPWR u_ppwm_u_mem__0617_/Y net410 hold42/A u_ppwm_u_mem__1029_/Y
+ sg13g2_a21oi_1
XFILLER_44_663 VPWR VGND sg13g2_decap_8
XFILLER_43_151 VPWR VGND sg13g2_decap_4
XFILLER_16_365 VPWR VGND sg13g2_decap_4
XFILLER_17_888 VPWR VGND sg13g2_decap_8
XFILLER_32_858 VPWR VGND sg13g2_decap_8
XFILLER_31_357 VPWR VGND sg13g2_decap_8
XFILLER_40_891 VPWR VGND sg13g2_decap_8
XFILLER_8_542 VPWR VGND sg13g2_decap_8
Xu_ppwm_u_mem__0814_ hold286/A u_ppwm_u_mem__0811_/X u_ppwm_u_mem__0813_/X u_ppwm_u_mem__0810_/X
+ u_ppwm_u_mem__0812_/X net461 u_ppwm_u_mem__0815_/B VPWR VGND sg13g2_mux4_1
Xu_ppwm_u_ex__0602_ VPWR u_ppwm_u_ex__0602_/Y hold268/A VGND sg13g2_inv_1
Xclkbuf_5_9__f_clk clknet_4_4_0_clk clknet_5_9__leaf_clk VPWR VGND sg13g2_buf_8
Xu_ppwm_u_mem__0745_ net451 VPWR u_ppwm_u_mem__0745_/Y VGND u_ppwm_u_mem__0741_/Y
+ u_ppwm_u_mem__0744_/Y sg13g2_o21ai_1
Xu_ppwm_u_mem__0676_ VPWR u_ppwm_u_mem__0676_/Y net327 VGND sg13g2_inv_1
XFILLER_4_781 VPWR VGND sg13g2_decap_8
XFILLER_39_424 VPWR VGND sg13g2_fill_1
XFILLER_39_479 VPWR VGND sg13g2_decap_8
XFILLER_19_192 VPWR VGND sg13g2_fill_2
Xu_ppwm_u_ex__1016_ u_ppwm_u_ex__1016_/A u_ppwm_u_ex__1016_/B u_ppwm_u_ex__1018_/A
+ VPWR VGND sg13g2_and2_1
Xu_ppwm_u_mem__1159_ net131 VGND VPWR net299 hold81/A clknet_5_3__leaf_clk sg13g2_dfrbpq_1
XFILLER_35_674 VPWR VGND sg13g2_decap_8
XFILLER_23_847 VPWR VGND sg13g2_decap_8
XFILLER_31_880 VPWR VGND sg13g2_decap_8
XFILLER_2_718 VPWR VGND sg13g2_decap_8
XFILLER_44_1020 VPWR VGND sg13g2_decap_8
XFILLER_26_641 VPWR VGND sg13g2_decap_8
XFILLER_38_490 VPWR VGND sg13g2_decap_8
XFILLER_14_814 VPWR VGND sg13g2_decap_8
XFILLER_41_622 VPWR VGND sg13g2_decap_8
XFILLER_15_52 VPWR VGND sg13g2_decap_8
XFILLER_41_699 VPWR VGND sg13g2_decap_8
XFILLER_13_379 VPWR VGND sg13g2_fill_1
XFILLER_5_545 VPWR VGND sg13g2_decap_8
Xu_ppwm_u_mem__1101__148 VPWR VGND net148 sg13g2_tiehi
XFILLER_1_762 VPWR VGND sg13g2_decap_8
XFILLER_49_733 VPWR VGND sg13g2_decap_8
XFILLER_37_917 VPWR VGND sg13g2_decap_8
Xu_ppwm_u_mem__1013_ net503 VPWR u_ppwm_u_mem__1013_/Y VGND net524 net408 sg13g2_o21ai_1
XFILLER_44_460 VPWR VGND sg13g2_decap_8
XFILLER_17_685 VPWR VGND sg13g2_decap_8
XFILLER_32_655 VPWR VGND sg13g2_decap_8
XFILLER_20_839 VPWR VGND sg13g2_decap_8
XFILLER_31_154 VPWR VGND sg13g2_fill_2
XFILLER_28_1015 VPWR VGND sg13g2_decap_8
Xu_ppwm_u_mem__0728_ net454 VPWR u_ppwm_u_mem__0728_/Y VGND u_ppwm_u_mem__0726_/Y
+ u_ppwm_u_mem__0727_/Y sg13g2_o21ai_1
Xu_ppwm_u_mem__0659_ VPWR u_ppwm_u_mem__0659_/Y net555 VGND sg13g2_inv_1
XFILLER_28_917 VPWR VGND sg13g2_decap_8
XFILLER_27_449 VPWR VGND sg13g2_decap_8
XFILLER_23_644 VPWR VGND sg13g2_decap_8
XFILLER_10_349 VPWR VGND sg13g2_fill_1
XFILLER_2_515 VPWR VGND sg13g2_decap_8
XFILLER_7_6 VPWR VGND sg13g2_fill_1
Xclkbuf_4_13_0_clk clknet_0_clk clknet_4_13_0_clk VPWR VGND sg13g2_buf_8
XFILLER_18_416 VPWR VGND sg13g2_fill_1
XFILLER_19_928 VPWR VGND sg13g2_decap_8
XFILLER_46_769 VPWR VGND sg13g2_decap_8
XFILLER_33_419 VPWR VGND sg13g2_decap_4
XFILLER_45_279 VPWR VGND sg13g2_fill_1
XFILLER_14_611 VPWR VGND sg13g2_decap_8
XFILLER_13_110 VPWR VGND sg13g2_decap_8
XFILLER_42_986 VPWR VGND sg13g2_decap_8
XFILLER_14_688 VPWR VGND sg13g2_decap_8
XFILLER_41_496 VPWR VGND sg13g2_decap_8
Xu_ppwm_u_pwm__252_ net200 VGND VPWR net236 hold18/A clknet_5_6__leaf_clk sg13g2_dfrbpq_1
XFILLER_13_187 VPWR VGND sg13g2_fill_1
Xu_ppwm_u_pwm__183_ VGND VPWR u_ppwm_u_pwm__136_/Y net378 hold170/A u_ppwm_u_pwm__182_/Y
+ sg13g2_a21oi_1
XFILLER_10_894 VPWR VGND sg13g2_decap_8
XFILLER_6_876 VPWR VGND sg13g2_decap_8
XFILLER_47_7 VPWR VGND sg13g2_decap_4
XFILLER_3_11 VPWR VGND sg13g2_decap_8
XFILLER_49_530 VPWR VGND sg13g2_decap_8
XFILLER_37_714 VPWR VGND sg13g2_decap_8
XFILLER_17_482 VPWR VGND sg13g2_decap_8
XFILLER_33_942 VPWR VGND sg13g2_decap_8
XFILLER_20_636 VPWR VGND sg13g2_decap_8
Xu_ppwm_u_ex__0996_ u_ppwm_u_ex__0996_/Y hold264/A net373 VPWR VGND sg13g2_nand2_1
XFILLER_47_17 VPWR VGND sg13g2_decap_8
XFILLER_28_714 VPWR VGND sg13g2_decap_8
XFILLER_23_441 VPWR VGND sg13g2_decap_8
XFILLER_24_964 VPWR VGND sg13g2_decap_8
XFILLER_35_290 VPWR VGND sg13g2_fill_1
XFILLER_11_647 VPWR VGND sg13g2_decap_8
XFILLER_10_157 VPWR VGND sg13g2_decap_8
Xu_ppwm_u_pwm__234__196 VPWR VGND net196 sg13g2_tiehi
XFILLER_3_868 VPWR VGND sg13g2_decap_8
Xhold180 hold180/A VPWR VGND net563 sg13g2_dlygate4sd3_1
XFILLER_2_389 VPWR VGND sg13g2_decap_8
Xhold191 hold191/A VPWR VGND net574 sg13g2_dlygate4sd3_1
XFILLER_19_725 VPWR VGND sg13g2_decap_8
XFILLER_46_566 VPWR VGND sg13g2_decap_8
XFILLER_34_717 VPWR VGND sg13g2_decap_8
XFILLER_15_920 VPWR VGND sg13g2_decap_8
XFILLER_18_279 VPWR VGND sg13g2_fill_2
XFILLER_33_227 VPWR VGND sg13g2_fill_1
XFILLER_14_430 VPWR VGND sg13g2_fill_2
XFILLER_33_238 VPWR VGND sg13g2_fill_2
XFILLER_42_783 VPWR VGND sg13g2_decap_8
XFILLER_15_997 VPWR VGND sg13g2_decap_8
XFILLER_14_485 VPWR VGND sg13g2_decap_8
Xu_ppwm_u_ex__0850_ u_ppwm_u_ex__0933_/B u_ppwm_u_ex__0874_/B u_ppwm_u_ex__0850_/C
+ u_ppwm_u_ex__0850_/Y VPWR VGND sg13g2_nor3_1
XFILLER_30_934 VPWR VGND sg13g2_decap_8
Xu_ppwm_u_ex__0781_ u_ppwm_u_ex__0782_/B net347 u_ppwm_u_ex__0779_/B u_ppwm_u_ex__0779_/Y
+ net225 VPWR VGND sg13g2_a22oi_1
Xu_ppwm_u_mem__0993_ net483 VPWR u_ppwm_u_mem__0993_/Y VGND net249 net385 sg13g2_o21ai_1
Xu_ppwm_u_pwm__235_ net207 VGND VPWR net589 hold205/A clknet_5_0__leaf_clk sg13g2_dfrbpq_2
Xu_ppwm_u_pwm__166_ net619 u_ppwm_u_pwm__166_/B u_ppwm_u_pwm__171_/C VPWR VGND sg13g2_and2_1
XFILLER_10_691 VPWR VGND sg13g2_decap_8
XFILLER_6_673 VPWR VGND sg13g2_decap_8
XFILLER_37_511 VPWR VGND sg13g2_decap_8
XFILLER_25_739 VPWR VGND sg13g2_decap_8
XFILLER_37_588 VPWR VGND sg13g2_decap_8
XFILLER_40_709 VPWR VGND sg13g2_decap_8
XFILLER_24_238 VPWR VGND sg13g2_decap_8
XFILLER_32_260 VPWR VGND sg13g2_decap_4
XFILLER_20_455 VPWR VGND sg13g2_fill_1
XFILLER_21_967 VPWR VGND sg13g2_decap_8
Xu_ppwm_u_ex__0979_ VGND VPWR u_ppwm_u_ex__0977_/Y u_ppwm_u_ex__0978_/X u_ppwm_u_ex__0979_/Y
+ net349 sg13g2_a21oi_1
XFILLER_0_805 VPWR VGND sg13g2_decap_8
Xheichips25_ppwm_10 VPWR VGND uio_oe[6] sg13g2_tielo
Xheichips25_ppwm_21 VPWR VGND uo_out[2] sg13g2_tielo
XFILLER_28_511 VPWR VGND sg13g2_decap_8
XFILLER_28_588 VPWR VGND sg13g2_decap_8
XFILLER_43_547 VPWR VGND sg13g2_decap_8
XFILLER_15_227 VPWR VGND sg13g2_fill_1
XFILLER_12_912 VPWR VGND sg13g2_decap_8
XFILLER_24_761 VPWR VGND sg13g2_decap_8
XFILLER_30_219 VPWR VGND sg13g2_fill_2
XFILLER_8_927 VPWR VGND sg13g2_decap_8
XFILLER_12_989 VPWR VGND sg13g2_decap_8
XFILLER_3_665 VPWR VGND sg13g2_decap_8
XFILLER_47_842 VPWR VGND sg13g2_decap_8
Xfanout490 net491 net490 VPWR VGND sg13g2_buf_8
XFILLER_19_522 VPWR VGND sg13g2_decap_8
Xu_ppwm_u_mem__1192_ net184 VGND VPWR u_ppwm_u_mem__1192_/D hold126/A clknet_5_24__leaf_clk
+ sg13g2_dfrbpq_1
XFILLER_0_56 VPWR VGND sg13g2_decap_4
XFILLER_19_599 VPWR VGND sg13g2_decap_8
XFILLER_34_514 VPWR VGND sg13g2_decap_8
XFILLER_21_208 VPWR VGND sg13g2_fill_1
Xu_ppwm_u_ex__1118__39 VPWR VGND net39 sg13g2_tiehi
XFILLER_42_580 VPWR VGND sg13g2_decap_8
XFILLER_9_54 VPWR VGND sg13g2_fill_2
Xu_ppwm_u_ex__0902_ u_ppwm_u_ex__0903_/B net356 hold262/A net358 net427 VPWR VGND
+ sg13g2_a22oi_1
Xu_ppwm_u_ex__1126__50 VPWR VGND net50 sg13g2_tiehi
XFILLER_15_794 VPWR VGND sg13g2_decap_8
XFILLER_30_731 VPWR VGND sg13g2_decap_8
Xu_ppwm_u_ex__0833_ u_ppwm_u_ex__0833_/Y net449 net370 VPWR VGND sg13g2_nand2_1
Xu_ppwm_u_ex__0764_ net432 hold291/A u_ppwm_u_ex__0764_/Y VPWR VGND sg13g2_nor2b_1
Xu_ppwm_u_pwm__218_ u_ppwm_u_pwm__227_/A u_ppwm_u_pwm__222_/A u_ppwm_u_pwm__222_/B
+ VPWR VGND sg13g2_nand2_1
XFILLER_7_960 VPWR VGND sg13g2_decap_8
Xu_ppwm_u_mem__0976_ VGND VPWR u_ppwm_u_mem__0644_/Y net387 u_ppwm_u_mem__1158_/D
+ u_ppwm_u_mem__0975_/Y sg13g2_a21oi_1
XFILLER_6_470 VPWR VGND sg13g2_decap_8
Xu_ppwm_u_ex__0695_ u_ppwm_u_ex__0694_/Y VPWR u_ppwm_u_ex__0699_/A VGND hold298/A
+ u_ppwm_u_ex__0896_/A sg13g2_o21ai_1
Xu_ppwm_u_pwm__149_ VGND VPWR u_ppwm_u_pwm__154_/A net588 hold214/A net596 sg13g2_a21oi_1
XFILLER_36_0 VPWR VGND sg13g2_decap_8
Xu_ppwm_u_global_counter__167_ net72 VGND VPWR u_ppwm_u_global_counter__167_/D hold284/A
+ clknet_5_5__leaf_clk sg13g2_dfrbpq_2
XFILLER_38_875 VPWR VGND sg13g2_decap_8
Xu_ppwm_u_global_counter__098_ u_ppwm_u_global_counter__120_/B net671 VPWR VGND sg13g2_inv_2
XFILLER_25_536 VPWR VGND sg13g2_decap_8
XFILLER_40_506 VPWR VGND sg13g2_decap_8
XFILLER_21_764 VPWR VGND sg13g2_decap_8
XFILLER_0_602 VPWR VGND sg13g2_decap_8
XFILLER_0_679 VPWR VGND sg13g2_decap_8
XFILLER_48_639 VPWR VGND sg13g2_decap_8
XFILLER_47_127 VPWR VGND sg13g2_decap_4
XFILLER_28_341 VPWR VGND sg13g2_fill_2
XFILLER_29_864 VPWR VGND sg13g2_decap_8
XFILLER_44_845 VPWR VGND sg13g2_decap_8
XFILLER_16_569 VPWR VGND sg13g2_decap_8
XFILLER_34_73 VPWR VGND sg13g2_decap_8
Xu_ppwm_u_mem__0830_ net462 u_ppwm_u_mem__0829_/X u_ppwm_u_mem__0828_/X u_ppwm_u_mem__0826_/X
+ u_ppwm_u_mem__0827_/X net456 u_ppwm_u_mem__0831_/B VPWR VGND sg13g2_mux4_1
XFILLER_8_724 VPWR VGND sg13g2_decap_8
XFILLER_12_786 VPWR VGND sg13g2_decap_8
Xu_ppwm_u_mem__0761_ net451 VPWR u_ppwm_u_mem__0761_/Y VGND u_ppwm_u_mem__0757_/Y
+ u_ppwm_u_mem__0758_/Y sg13g2_o21ai_1
Xu_ppwm_u_mem__0692_ VPWR u_ppwm_u_mem__0692_/Y net245 VGND sg13g2_inv_1
XFILLER_4_963 VPWR VGND sg13g2_decap_8
XFILLER_3_462 VPWR VGND sg13g2_decap_8
Xu_ppwm_u_ex__1101_ net482 VPWR u_ppwm_u_ex__1102_/B VGND net431 net341 sg13g2_o21ai_1
XFILLER_38_127 VPWR VGND sg13g2_fill_1
Xu_ppwm_u_ex__1032_ u_ppwm_u_ex__1031_/Y u_ppwm_u_ex__1030_/Y net352 u_ppwm_u_ex__1033_/D
+ VPWR VGND sg13g2_a21o_1
XFILLER_19_374 VPWR VGND sg13g2_fill_2
XFILLER_46_182 VPWR VGND sg13g2_fill_2
Xu_ppwm_u_mem__1134__83 VPWR VGND net83 sg13g2_tiehi
Xu_ppwm_u_mem__1175_ net186 VGND VPWR net302 hold84/A clknet_5_29__leaf_clk sg13g2_dfrbpq_1
XFILLER_35_856 VPWR VGND sg13g2_decap_8
Xu_ppwm_u_mem__1111__128 VPWR VGND net128 sg13g2_tiehi
XFILLER_22_539 VPWR VGND sg13g2_decap_8
Xu_ppwm_u_global_counter__179__69 VPWR VGND net69 sg13g2_tiehi
XFILLER_15_591 VPWR VGND sg13g2_decap_8
Xu_ppwm_u_ex__0816_ u_ppwm_u_ex__0999_/A net345 u_ppwm_u_ex__0816_/Y VPWR VGND sg13g2_nor2b_1
Xu_ppwm_u_ex__0747_ u_ppwm_u_ex__0729_/Y VPWR u_ppwm_u_ex__0750_/A VGND u_ppwm_u_ex__0743_/Y
+ u_ppwm_u_ex__0746_/Y sg13g2_o21ai_1
Xu_ppwm_u_mem__0959_ net487 VPWR u_ppwm_u_mem__0959_/Y VGND hold117/A net389 sg13g2_o21ai_1
Xu_ppwm_u_ex__0678_ u_ppwm_u_ex__0789_/A u_ppwm/instr\[1\] net475 u_ppwm_u_ex__0678_/Y
+ VPWR VGND u_ppwm/instr\[2\] sg13g2_nand4_1
XFILLER_26_823 VPWR VGND sg13g2_decap_8
XFILLER_38_672 VPWR VGND sg13g2_decap_8
XFILLER_41_804 VPWR VGND sg13g2_decap_8
XFILLER_13_539 VPWR VGND sg13g2_decap_8
XFILLER_25_377 VPWR VGND sg13g2_decap_4
XFILLER_21_561 VPWR VGND sg13g2_decap_8
XFILLER_5_727 VPWR VGND sg13g2_decap_8
XFILLER_4_204 VPWR VGND sg13g2_fill_1
XFILLER_1_944 VPWR VGND sg13g2_decap_8
XFILLER_49_915 VPWR VGND sg13g2_decap_8
XFILLER_48_436 VPWR VGND sg13g2_decap_8
XFILLER_0_476 VPWR VGND sg13g2_decap_8
Xhold40 hold40/A VPWR VGND net257 sg13g2_dlygate4sd3_1
Xhold73 hold73/A VPWR VGND net290 sg13g2_dlygate4sd3_1
Xhold62 hold62/A VPWR VGND net279 sg13g2_dlygate4sd3_1
XFILLER_29_73 VPWR VGND sg13g2_decap_4
Xhold51 hold51/A VPWR VGND net268 sg13g2_dlygate4sd3_1
Xhold95 hold95/A VPWR VGND net312 sg13g2_dlygate4sd3_1
XFILLER_29_661 VPWR VGND sg13g2_decap_8
Xhold84 hold84/A VPWR VGND net301 sg13g2_dlygate4sd3_1
XFILLER_35_108 VPWR VGND sg13g2_fill_1
XFILLER_44_642 VPWR VGND sg13g2_decap_8
XFILLER_28_171 VPWR VGND sg13g2_decap_8
XFILLER_16_344 VPWR VGND sg13g2_decap_4
XFILLER_17_867 VPWR VGND sg13g2_decap_8
XFILLER_32_837 VPWR VGND sg13g2_decap_8
XFILLER_40_870 VPWR VGND sg13g2_decap_8
XFILLER_8_521 VPWR VGND sg13g2_decap_8
XFILLER_12_583 VPWR VGND sg13g2_decap_8
Xu_ppwm_u_mem__0813_ hold17/A hold150/A net472 u_ppwm_u_mem__0813_/X VPWR VGND sg13g2_mux2_1
XFILLER_8_598 VPWR VGND sg13g2_decap_8
XFILLER_6_33 VPWR VGND sg13g2_fill_1
Xu_ppwm_u_ex__0601_ VPWR u_ppwm_u_ex__0601_/Y net424 VGND sg13g2_inv_1
Xu_ppwm_u_mem__0744_ net454 VPWR u_ppwm_u_mem__0744_/Y VGND u_ppwm_u_mem__0742_/Y
+ u_ppwm_u_mem__0743_/Y sg13g2_o21ai_1
XFILLER_4_760 VPWR VGND sg13g2_decap_8
Xu_ppwm_u_mem__0675_ VPWR u_ppwm_u_mem__0675_/Y net544 VGND sg13g2_inv_1
XFILLER_39_403 VPWR VGND sg13g2_fill_1
XFILLER_39_458 VPWR VGND sg13g2_decap_8
Xu_ppwm_u_ex__1015_ u_ppwm_u_ex__1040_/A net439 net366 VPWR VGND sg13g2_xnor2_1
Xu_ppwm_u_mem__1158_ net135 VGND VPWR u_ppwm_u_mem__1158_/D hold194/A clknet_5_7__leaf_clk
+ sg13g2_dfrbpq_1
XFILLER_35_653 VPWR VGND sg13g2_decap_8
XFILLER_23_826 VPWR VGND sg13g2_decap_8
Xu_ppwm_u_mem__1089_ net172 VGND VPWR net275 hold57/A clknet_5_10__leaf_clk sg13g2_dfrbpq_1
XFILLER_10_509 VPWR VGND sg13g2_decap_8
Xu_ppwm_u_mem__1196__133 VPWR VGND net133 sg13g2_tiehi
Xu_ppwm_u_mem__1157__139 VPWR VGND net139 sg13g2_tiehi
XFILLER_45_417 VPWR VGND sg13g2_fill_1
XFILLER_26_620 VPWR VGND sg13g2_decap_8
XFILLER_41_601 VPWR VGND sg13g2_decap_8
XFILLER_26_697 VPWR VGND sg13g2_decap_8
XFILLER_13_358 VPWR VGND sg13g2_decap_4
XFILLER_41_678 VPWR VGND sg13g2_decap_8
XFILLER_9_329 VPWR VGND sg13g2_fill_1
XFILLER_9_318 VPWR VGND sg13g2_fill_1
XFILLER_5_524 VPWR VGND sg13g2_decap_8
XFILLER_1_741 VPWR VGND sg13g2_decap_8
XFILLER_49_712 VPWR VGND sg13g2_decap_8
XFILLER_49_789 VPWR VGND sg13g2_decap_8
XFILLER_48_277 VPWR VGND sg13g2_fill_1
XFILLER_17_664 VPWR VGND sg13g2_decap_8
Xu_ppwm_u_mem__1012_ VGND VPWR u_ppwm_u_mem__0626_/Y net417 hold146/A u_ppwm_u_mem__1011_/Y
+ sg13g2_a21oi_1
XFILLER_45_984 VPWR VGND sg13g2_decap_8
XFILLER_32_634 VPWR VGND sg13g2_decap_8
XFILLER_20_818 VPWR VGND sg13g2_decap_8
XFILLER_31_166 VPWR VGND sg13g2_decap_8
XFILLER_9_885 VPWR VGND sg13g2_decap_8
Xu_ppwm_u_mem__0727_ net458 VPWR u_ppwm_u_mem__0727_/Y VGND hold134/A net467 sg13g2_o21ai_1
Xu_ppwm_u_mem__0658_ VPWR u_ppwm_u_mem__0658_/Y net548 VGND sg13g2_inv_1
.ends
